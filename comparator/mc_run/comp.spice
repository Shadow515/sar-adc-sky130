* StrongARM latch comparator (sky130)
.subckt comp clk inp inn outp outn VDD GND
* tail switch: turns the comparator on when clk is high
XM0 tail clk GND GND sky130_fd_pr__nfet_01v8 L=0.15 W=2 nf=1
* input pair: the "race"
XM1 X inp tail GND sky130_fd_pr__nfet_01v8 L=1 W=8 nf=1
XM2 Y inn tail GND sky130_fd_pr__nfet_01v8 L=1 W=8 nf=1
* cross-coupled pair: positive feedback
XM3 outn outp X GND sky130_fd_pr__nfet_01v8 L=0.15 W=1 nf=1
XM4 outp outn Y GND sky130_fd_pr__nfet_01v8 L=0.15 W=1 nf=1
XM5 outn outp VDD VDD sky130_fd_pr__pfet_01v8 L=0.15 W=2 nf=1
XM6 outp outn VDD VDD sky130_fd_pr__pfet_01v8 L=0.15 W=2 nf=1
* reset switches: pull everything to VDD when clk is low
XM7 outn clk VDD VDD sky130_fd_pr__pfet_01v8 L=0.15 W=1 nf=1
XM8 outp clk VDD VDD sky130_fd_pr__pfet_01v8 L=0.15 W=1 nf=1
XM9 X clk VDD VDD sky130_fd_pr__pfet_01v8 L=0.15 W=1 nf=1
XM10 Y clk VDD VDD sky130_fd_pr__pfet_01v8 L=0.15 W=1 nf=1
.ends
