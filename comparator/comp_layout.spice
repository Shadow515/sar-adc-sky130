* NGSPICE file created from comp.ext - technology: sky130A

.subckt sky130_fd_pr__pfet_01v8_7HN6Y2 B D S G
X0 S G D B sky130_fd_pr__pfet_01v8 ad=0.29 pd=2.58 as=0.29 ps=2.58 w=1 l=0.15
.ends

.subckt sky130_fd_pr__nfet_01v8_NK2ZG9 B D S G
X0 S G D B sky130_fd_pr__nfet_01v8 ad=0.58 pd=4.58 as=0.58 ps=4.58 w=2 l=0.15
.ends

.subckt sky130_fd_pr__nfet_01v8_TPXDG7 B D S G
X0 S G D B sky130_fd_pr__nfet_01v8 ad=2.32 pd=16.58 as=2.32 ps=16.58 w=8 l=1
.ends

.subckt sky130_fd_pr__nfet_01v8_34VMYE B D S G
X0 S G D B sky130_fd_pr__nfet_01v8 ad=0.29 pd=2.58 as=0.29 ps=2.58 w=1 l=0.15
.ends

.subckt sky130_fd_pr__pfet_01v8_VJT448 B D S G
X0 S G D B sky130_fd_pr__pfet_01v8 ad=0.58 pd=4.58 as=0.58 ps=4.58 w=2 l=0.15
.ends

.subckt comp clk inp inn outp outn VDD GND
XM10 VDD M4/S VDD clk sky130_fd_pr__pfet_01v8_7HN6Y2
XM0 GND GND M2/D clk sky130_fd_pr__nfet_01v8_NK2ZG9
XM1 GND M9/S M2/D inp sky130_fd_pr__nfet_01v8_TPXDG7
XM2 GND M2/D M4/S inn sky130_fd_pr__nfet_01v8_TPXDG7
XM4 GND outp M4/S outn sky130_fd_pr__nfet_01v8_34VMYE
XM3 GND M9/S outn outp sky130_fd_pr__nfet_01v8_34VMYE
XM5 VDD VDD outn outp sky130_fd_pr__pfet_01v8_VJT448
XM6 VDD outp VDD outn sky130_fd_pr__pfet_01v8_VJT448
XM7 VDD VDD outn clk sky130_fd_pr__pfet_01v8_7HN6Y2
XM8 VDD outp VDD clk sky130_fd_pr__pfet_01v8_7HN6Y2
XM9 VDD VDD M9/S clk sky130_fd_pr__pfet_01v8_7HN6Y2
.ends
