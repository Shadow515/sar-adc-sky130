* Comparator offset test (one random chip)
.lib /foss/pdks/sky130A/libs.tech/ngspice/sky130.lib.spice tt_mm
.include comp.spice
Xcomp clk inp inn outp outn VDD 0 comp
Vdd VDD 0 1.8
Vclk clk 0 pulse(0 1.8 0.5n 50p 50p 1.9n 4n)
Vinn inn 0 0.9
Vinp inp 0 pwl(0 0.85 800n 0.95)
Cp outp 0 5f
Cn outn 0 5f
.control
tran 20p 800n
let vd = v(outp) - v(outn)
meas tran tflip when vd=0.9 rise=1
let off_mv = (0.85 + 0.1*tflip/800e-9 - 0.9)*1000
print off_mv
.endc
.end
