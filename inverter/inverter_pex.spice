* SPICE3 file created from inverter.ext - technology: sky130A

.subckt inverter in out VDD GND
X0 out in GND GND sky130_fd_pr__nfet_01v8 ad=0.29 pd=2.58 as=0.29 ps=2.58 w=1 l=0.15
X1 out in VDD VDD sky130_fd_pr__pfet_01v8 ad=0.58 pd=4.58 as=0.58 ps=4.58 w=2 l=0.15
C0 out in 0.17349f
C1 in VDD 0.3064f
C2 out VDD 0.35617f
C3 in GND 0.4751f
C4 out GND 0.40207f
C5 VDD GND 1.51014f
.ends
