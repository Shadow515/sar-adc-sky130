* NGSPICE file created from swunit.ext - technology: sky130A

.subckt sky130_fd_pr__nfet_01v8_PHAC7Z B D S G
X0 S G D B sky130_fd_pr__nfet_01v8 ad=0.145 pd=1.58 as=0.145 ps=1.58 w=0.5 l=0.15
.ends

.subckt sky130_fd_pr__pfet_01v8_7HN6Y2 B D S G
X0 S G D B sky130_fd_pr__pfet_01v8 ad=0.29 pd=2.58 as=0.29 ps=2.58 w=1 l=0.15
.ends

.subckt swunit b vin vref p n s sb VDD GND
XMN GND b GND n sky130_fd_pr__nfet_01v8_PHAC7Z
XMP VDD b vref p sky130_fd_pr__pfet_01v8_7HN6Y2
XMS1 GND vin b s sky130_fd_pr__nfet_01v8_PHAC7Z
XMS2 VDD vin b sb sky130_fd_pr__pfet_01v8_7HN6Y2
.ends
