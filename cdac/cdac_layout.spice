* NGSPICE file created from cdac_array.ext - technology: sky130A

.subckt sky130_fd_pr__cap_mim_m3_1_4V3HYR C2 C1
X0 C1 C2 sky130_fd_pr__cap_mim_m3_1 l=2 w=2
.ends

.subckt cdac_array top b0 b1 b2 b3 b4 b5 b6 b7 bd
XC12_3_b5 b5 top sky130_fd_pr__cap_mim_m3_1_4V3HYR
XC9_13_b7 b7 top sky130_fd_pr__cap_mim_m3_1_4V3HYR
XC0_15_b7 b7 top sky130_fd_pr__cap_mim_m3_1_4V3HYR
XC11_5_b6 b6 top sky130_fd_pr__cap_mim_m3_1_4V3HYR
XC10_4_b7 b7 top sky130_fd_pr__cap_mim_m3_1_4V3HYR
XC14_8_b3 b3 top sky130_fd_pr__cap_mim_m3_1_4V3HYR
XC13_7_b4 b4 top sky130_fd_pr__cap_mim_m3_1_4V3HYR
XC11_2_b7 b7 top sky130_fd_pr__cap_mim_m3_1_4V3HYR
XC7_10_b6 b6 top sky130_fd_pr__cap_mim_m3_1_4V3HYR
XC0_3_b5 b5 top sky130_fd_pr__cap_mim_m3_1_4V3HYR
XC13_1_b6 b6 top sky130_fd_pr__cap_mim_m3_1_4V3HYR
XC12_0_b7 b7 top sky130_fd_pr__cap_mim_m3_1_4V3HYR
XC8_13_b7 b7 top sky130_fd_pr__cap_mim_m3_1_4V3HYR
XC1_7_b4 b4 top sky130_fd_pr__cap_mim_m3_1_4V3HYR
XC2_8_b3 b3 top sky130_fd_pr__cap_mim_m3_1_4V3HYR
XC6_10_b6 b6 top sky130_fd_pr__cap_mim_m3_1_4V3HYR
XC0_0_b7 b7 top sky130_fd_pr__cap_mim_m3_1_4V3HYR
XC1_1_b6 b6 top sky130_fd_pr__cap_mim_m3_1_4V3HYR
XC7_13_b7 b7 top sky130_fd_pr__cap_mim_m3_1_4V3HYR
XC15_3_b5 b5 top sky130_fd_pr__cap_mim_m3_1_4V3HYR
XC12_6_b7 b7 top sky130_fd_pr__cap_mim_m3_1_4V3HYR
XC13_4_b7 b7 top sky130_fd_pr__cap_mim_m3_1_4V3HYR
XC14_5_b6 b6 top sky130_fd_pr__cap_mim_m3_1_4V3HYR
XC12_9_b7 b7 top sky130_fd_pr__cap_mim_m3_1_4V3HYR
XC5_8_b2 b2 top sky130_fd_pr__cap_mim_m3_1_4V3HYR
XC5_10_b6 b6 top sky130_fd_pr__cap_mim_m3_1_4V3HYR
XC15_14_b6 b6 top sky130_fd_pr__cap_mim_m3_1_4V3HYR
XC14_2_b7 b7 top sky130_fd_pr__cap_mim_m3_1_4V3HYR
XC0_6_b7 b7 top sky130_fd_pr__cap_mim_m3_1_4V3HYR
XC3_3_b5 b5 top sky130_fd_pr__cap_mim_m3_1_4V3HYR
XC15_11_b7 b7 top sky130_fd_pr__cap_mim_m3_1_4V3HYR
XC15_0_b7 b7 top sky130_fd_pr__cap_mim_m3_1_4V3HYR
XC6_13_b7 b7 top sky130_fd_pr__cap_mim_m3_1_4V3HYR
XC1_4_b7 b7 top sky130_fd_pr__cap_mim_m3_1_4V3HYR
XC0_9_b7 b7 top sky130_fd_pr__cap_mim_m3_1_4V3HYR
XC2_5_b6 b6 top sky130_fd_pr__cap_mim_m3_1_4V3HYR
XC2_2_b7 b7 top sky130_fd_pr__cap_mim_m3_1_4V3HYR
XC4_7_b4 b4 top sky130_fd_pr__cap_mim_m3_1_4V3HYR
XC3_0_b7 b7 top sky130_fd_pr__cap_mim_m3_1_4V3HYR
XC4_10_b6 b6 top sky130_fd_pr__cap_mim_m3_1_4V3HYR
XC14_14_b6 b6 top sky130_fd_pr__cap_mim_m3_1_4V3HYR
XC4_1_b6 b6 top sky130_fd_pr__cap_mim_m3_1_4V3HYR
XC5_13_b7 b7 top sky130_fd_pr__cap_mim_m3_1_4V3HYR
XC14_11_b7 b7 top sky130_fd_pr__cap_mim_m3_1_4V3HYR
XC15_6_b7 b7 top sky130_fd_pr__cap_mim_m3_1_4V3HYR
XC15_9_b7 b7 top sky130_fd_pr__cap_mim_m3_1_4V3HYR
XC13_14_b6 b6 top sky130_fd_pr__cap_mim_m3_1_4V3HYR
XC6_3_b5 b5 top sky130_fd_pr__cap_mim_m3_1_4V3HYR
XC3_6_b7 b7 top sky130_fd_pr__cap_mim_m3_1_4V3HYR
XC3_10_b6 b6 top sky130_fd_pr__cap_mim_m3_1_4V3HYR
XC13_11_b7 b7 top sky130_fd_pr__cap_mim_m3_1_4V3HYR
XC4_13_b7 b7 top sky130_fd_pr__cap_mim_m3_1_4V3HYR
XC4_4_b7 b7 top sky130_fd_pr__cap_mim_m3_1_4V3HYR
XC5_5_b6 b6 top sky130_fd_pr__cap_mim_m3_1_4V3HYR
XC7_7_b4 b4 top sky130_fd_pr__cap_mim_m3_1_4V3HYR
XC3_9_b7 b7 top sky130_fd_pr__cap_mim_m3_1_4V3HYR
XC5_2_b7 b7 top sky130_fd_pr__cap_mim_m3_1_4V3HYR
XC2_10_b6 b6 top sky130_fd_pr__cap_mim_m3_1_4V3HYR
XC12_14_b6 b6 top sky130_fd_pr__cap_mim_m3_1_4V3HYR
XC7_1_b6 b6 top sky130_fd_pr__cap_mim_m3_1_4V3HYR
XC6_0_b7 b7 top sky130_fd_pr__cap_mim_m3_1_4V3HYR
XC12_11_b7 b7 top sky130_fd_pr__cap_mim_m3_1_4V3HYR
XC3_13_b7 b7 top sky130_fd_pr__cap_mim_m3_1_4V3HYR
XC10_8_b2 b2 top sky130_fd_pr__cap_mim_m3_1_4V3HYR
XC11_14_b6 b6 top sky130_fd_pr__cap_mim_m3_1_4V3HYR
XC1_10_b6 b6 top sky130_fd_pr__cap_mim_m3_1_4V3HYR
XC9_3_b5 b5 top sky130_fd_pr__cap_mim_m3_1_4V3HYR
XC6_6_b7 b7 top sky130_fd_pr__cap_mim_m3_1_4V3HYR
XC2_13_b7 b7 top sky130_fd_pr__cap_mim_m3_1_4V3HYR
XC11_11_b7 b7 top sky130_fd_pr__cap_mim_m3_1_4V3HYR
XC7_4_b7 b7 top sky130_fd_pr__cap_mim_m3_1_4V3HYR
XC8_5_b6 b6 top sky130_fd_pr__cap_mim_m3_1_4V3HYR
XC6_9_b7 b7 top sky130_fd_pr__cap_mim_m3_1_4V3HYR
XC8_2_b7 b7 top sky130_fd_pr__cap_mim_m3_1_4V3HYR
XC0_10_b6 b6 top sky130_fd_pr__cap_mim_m3_1_4V3HYR
XC10_14_b6 b6 top sky130_fd_pr__cap_mim_m3_1_4V3HYR
XC9_0_b7 b7 top sky130_fd_pr__cap_mim_m3_1_4V3HYR
XC10_11_b7 b7 top sky130_fd_pr__cap_mim_m3_1_4V3HYR
XC1_13_b7 b7 top sky130_fd_pr__cap_mim_m3_1_4V3HYR
XC11_3_b5 b5 top sky130_fd_pr__cap_mim_m3_1_4V3HYR
XC9_14_b6 b6 top sky130_fd_pr__cap_mim_m3_1_4V3HYR
XC9_11_b7 b7 top sky130_fd_pr__cap_mim_m3_1_4V3HYR
XC9_6_b7 b7 top sky130_fd_pr__cap_mim_m3_1_4V3HYR
XC0_13_b7 b7 top sky130_fd_pr__cap_mim_m3_1_4V3HYR
XC12_7_b4 b4 top sky130_fd_pr__cap_mim_m3_1_4V3HYR
XC10_5_b6 b6 top sky130_fd_pr__cap_mim_m3_1_4V3HYR
XC13_8_b3 b3 top sky130_fd_pr__cap_mim_m3_1_4V3HYR
XC10_2_b7 b7 top sky130_fd_pr__cap_mim_m3_1_4V3HYR
XC11_0_b7 b7 top sky130_fd_pr__cap_mim_m3_1_4V3HYR
XC9_9_b7 b7 top sky130_fd_pr__cap_mim_m3_1_4V3HYR
XC12_1_b6 b6 top sky130_fd_pr__cap_mim_m3_1_4V3HYR
XC8_14_b6 b6 top sky130_fd_pr__cap_mim_m3_1_4V3HYR
XC0_7_b4 b4 top sky130_fd_pr__cap_mim_m3_1_4V3HYR
XC8_11_b7 b7 top sky130_fd_pr__cap_mim_m3_1_4V3HYR
XC1_8_b3 b3 top sky130_fd_pr__cap_mim_m3_1_4V3HYR
XC0_1_b6 b6 top sky130_fd_pr__cap_mim_m3_1_4V3HYR
XC14_3_b5 b5 top sky130_fd_pr__cap_mim_m3_1_4V3HYR
XC11_6_b7 b7 top sky130_fd_pr__cap_mim_m3_1_4V3HYR
XC7_14_b6 b6 top sky130_fd_pr__cap_mim_m3_1_4V3HYR
XC7_11_b7 b7 top sky130_fd_pr__cap_mim_m3_1_4V3HYR
XC15_12_b5 b5 top sky130_fd_pr__cap_mim_m3_1_4V3HYR
XC13_5_b6 b6 top sky130_fd_pr__cap_mim_m3_1_4V3HYR
XC12_4_b7 b7 top sky130_fd_pr__cap_mim_m3_1_4V3HYR
XC15_7_b4 b4 top sky130_fd_pr__cap_mim_m3_1_4V3HYR
XC13_2_b7 b7 top sky130_fd_pr__cap_mim_m3_1_4V3HYR
XC11_9_b7 b7 top sky130_fd_pr__cap_mim_m3_1_4V3HYR
XC2_3_b5 b5 top sky130_fd_pr__cap_mim_m3_1_4V3HYR
XC4_8_b2 b2 top sky130_fd_pr__cap_mim_m3_1_4V3HYR
XC15_1_b6 b6 top sky130_fd_pr__cap_mim_m3_1_4V3HYR
XC14_0_b7 b7 top sky130_fd_pr__cap_mim_m3_1_4V3HYR
XC7_8_b0 b0 top sky130_fd_pr__cap_mim_m3_1_4V3HYR
XC6_14_b6 b6 top sky130_fd_pr__cap_mim_m3_1_4V3HYR
XC0_4_b7 b7 top sky130_fd_pr__cap_mim_m3_1_4V3HYR
XC1_5_b6 b6 top sky130_fd_pr__cap_mim_m3_1_4V3HYR
XC14_12_b5 b5 top sky130_fd_pr__cap_mim_m3_1_4V3HYR
XC6_11_b7 b7 top sky130_fd_pr__cap_mim_m3_1_4V3HYR
XC1_2_b7 b7 top sky130_fd_pr__cap_mim_m3_1_4V3HYR
XC3_7_b4 b4 top sky130_fd_pr__cap_mim_m3_1_4V3HYR
XC2_0_b7 b7 top sky130_fd_pr__cap_mim_m3_1_4V3HYR
XC3_1_b6 b6 top sky130_fd_pr__cap_mim_m3_1_4V3HYR
XC5_14_b6 b6 top sky130_fd_pr__cap_mim_m3_1_4V3HYR
XC14_6_b7 b7 top sky130_fd_pr__cap_mim_m3_1_4V3HYR
XC5_11_b7 b7 top sky130_fd_pr__cap_mim_m3_1_4V3HYR
XC15_15_b7 b7 top sky130_fd_pr__cap_mim_m3_1_4V3HYR
XC15_4_b7 b7 top sky130_fd_pr__cap_mim_m3_1_4V3HYR
XC13_12_b5 b5 top sky130_fd_pr__cap_mim_m3_1_4V3HYR
XC14_9_b7 b7 top sky130_fd_pr__cap_mim_m3_1_4V3HYR
XC2_6_b7 b7 top sky130_fd_pr__cap_mim_m3_1_4V3HYR
XC5_3_b5 b5 top sky130_fd_pr__cap_mim_m3_1_4V3HYR
XC3_4_b7 b7 top sky130_fd_pr__cap_mim_m3_1_4V3HYR
XC4_14_b6 b6 top sky130_fd_pr__cap_mim_m3_1_4V3HYR
XC12_12_b5 b5 top sky130_fd_pr__cap_mim_m3_1_4V3HYR
XC2_9_b7 b7 top sky130_fd_pr__cap_mim_m3_1_4V3HYR
XC4_5_b6 b6 top sky130_fd_pr__cap_mim_m3_1_4V3HYR
XC4_11_b7 b7 top sky130_fd_pr__cap_mim_m3_1_4V3HYR
XC14_15_b7 b7 top sky130_fd_pr__cap_mim_m3_1_4V3HYR
XC6_7_b4 b4 top sky130_fd_pr__cap_mim_m3_1_4V3HYR
XC4_2_b7 b7 top sky130_fd_pr__cap_mim_m3_1_4V3HYR
XC5_0_b7 b7 top sky130_fd_pr__cap_mim_m3_1_4V3HYR
XC6_1_b6 b6 top sky130_fd_pr__cap_mim_m3_1_4V3HYR
XC3_14_b6 b6 top sky130_fd_pr__cap_mim_m3_1_4V3HYR
XC13_15_b7 b7 top sky130_fd_pr__cap_mim_m3_1_4V3HYR
XC11_12_b5 b5 top sky130_fd_pr__cap_mim_m3_1_4V3HYR
XC3_11_b7 b7 top sky130_fd_pr__cap_mim_m3_1_4V3HYR
XC8_8_bd bd top sky130_fd_pr__cap_mim_m3_1_4V3HYR
XC8_3_b5 b5 top sky130_fd_pr__cap_mim_m3_1_4V3HYR
XC5_6_b7 b7 top sky130_fd_pr__cap_mim_m3_1_4V3HYR
XC2_14_b6 b6 top sky130_fd_pr__cap_mim_m3_1_4V3HYR
XC10_12_b5 b5 top sky130_fd_pr__cap_mim_m3_1_4V3HYR
XC7_5_b6 b6 top sky130_fd_pr__cap_mim_m3_1_4V3HYR
XC6_4_b7 b7 top sky130_fd_pr__cap_mim_m3_1_4V3HYR
XC2_11_b7 b7 top sky130_fd_pr__cap_mim_m3_1_4V3HYR
XC12_15_b7 b7 top sky130_fd_pr__cap_mim_m3_1_4V3HYR
XC9_7_b4 b4 top sky130_fd_pr__cap_mim_m3_1_4V3HYR
XC7_2_b7 b7 top sky130_fd_pr__cap_mim_m3_1_4V3HYR
XC5_9_b7 b7 top sky130_fd_pr__cap_mim_m3_1_4V3HYR
XC9_1_b6 b6 top sky130_fd_pr__cap_mim_m3_1_4V3HYR
XC8_0_b7 b7 top sky130_fd_pr__cap_mim_m3_1_4V3HYR
XC1_14_b6 b6 top sky130_fd_pr__cap_mim_m3_1_4V3HYR
XC11_15_b7 b7 top sky130_fd_pr__cap_mim_m3_1_4V3HYR
XC9_12_b5 b5 top sky130_fd_pr__cap_mim_m3_1_4V3HYR
XC1_11_b7 b7 top sky130_fd_pr__cap_mim_m3_1_4V3HYR
XC10_3_b5 b5 top sky130_fd_pr__cap_mim_m3_1_4V3HYR
XC8_6_b7 b7 top sky130_fd_pr__cap_mim_m3_1_4V3HYR
XC0_14_b6 b6 top sky130_fd_pr__cap_mim_m3_1_4V3HYR
XC12_8_b3 b3 top sky130_fd_pr__cap_mim_m3_1_4V3HYR
XC11_7_b4 b4 top sky130_fd_pr__cap_mim_m3_1_4V3HYR
XC9_4_b7 b7 top sky130_fd_pr__cap_mim_m3_1_4V3HYR
XC8_12_b5 b5 top sky130_fd_pr__cap_mim_m3_1_4V3HYR
XC0_11_b7 b7 top sky130_fd_pr__cap_mim_m3_1_4V3HYR
XC10_15_b7 b7 top sky130_fd_pr__cap_mim_m3_1_4V3HYR
XC8_9_b7 b7 top sky130_fd_pr__cap_mim_m3_1_4V3HYR
XC11_1_b6 b6 top sky130_fd_pr__cap_mim_m3_1_4V3HYR
XC10_0_b7 b7 top sky130_fd_pr__cap_mim_m3_1_4V3HYR
XC0_8_b3 b3 top sky130_fd_pr__cap_mim_m3_1_4V3HYR
XC9_15_b7 b7 top sky130_fd_pr__cap_mim_m3_1_4V3HYR
XC7_12_b5 b5 top sky130_fd_pr__cap_mim_m3_1_4V3HYR
XC13_3_b5 b5 top sky130_fd_pr__cap_mim_m3_1_4V3HYR
XC10_6_b7 b7 top sky130_fd_pr__cap_mim_m3_1_4V3HYR
XC11_4_b7 b7 top sky130_fd_pr__cap_mim_m3_1_4V3HYR
XC14_7_b4 b4 top sky130_fd_pr__cap_mim_m3_1_4V3HYR
XC12_5_b6 b6 top sky130_fd_pr__cap_mim_m3_1_4V3HYR
XC10_9_b7 b7 top sky130_fd_pr__cap_mim_m3_1_4V3HYR
XC6_12_b5 b5 top sky130_fd_pr__cap_mim_m3_1_4V3HYR
XC15_8_b3 b3 top sky130_fd_pr__cap_mim_m3_1_4V3HYR
XC12_2_b7 b7 top sky130_fd_pr__cap_mim_m3_1_4V3HYR
XC8_15_b7 b7 top sky130_fd_pr__cap_mim_m3_1_4V3HYR
XC1_3_b5 b5 top sky130_fd_pr__cap_mim_m3_1_4V3HYR
XC13_0_b7 b7 top sky130_fd_pr__cap_mim_m3_1_4V3HYR
XC14_1_b6 b6 top sky130_fd_pr__cap_mim_m3_1_4V3HYR
XC0_5_b6 b6 top sky130_fd_pr__cap_mim_m3_1_4V3HYR
XC15_10_b6 b6 top sky130_fd_pr__cap_mim_m3_1_4V3HYR
XC0_2_b7 b7 top sky130_fd_pr__cap_mim_m3_1_4V3HYR
XC2_7_b4 b4 top sky130_fd_pr__cap_mim_m3_1_4V3HYR
XC3_8_b3 b3 top sky130_fd_pr__cap_mim_m3_1_4V3HYR
XC7_15_b7 b7 top sky130_fd_pr__cap_mim_m3_1_4V3HYR
XC1_0_b7 b7 top sky130_fd_pr__cap_mim_m3_1_4V3HYR
XC5_12_b5 b5 top sky130_fd_pr__cap_mim_m3_1_4V3HYR
XC6_8_b1 b1 top sky130_fd_pr__cap_mim_m3_1_4V3HYR
XC2_1_b6 b6 top sky130_fd_pr__cap_mim_m3_1_4V3HYR
XC13_6_b7 b7 top sky130_fd_pr__cap_mim_m3_1_4V3HYR
XC14_10_b6 b6 top sky130_fd_pr__cap_mim_m3_1_4V3HYR
XC15_5_b6 b6 top sky130_fd_pr__cap_mim_m3_1_4V3HYR
XC14_4_b7 b7 top sky130_fd_pr__cap_mim_m3_1_4V3HYR
XC4_12_b5 b5 top sky130_fd_pr__cap_mim_m3_1_4V3HYR
XC15_13_b7 b7 top sky130_fd_pr__cap_mim_m3_1_4V3HYR
XC15_2_b7 b7 top sky130_fd_pr__cap_mim_m3_1_4V3HYR
XC13_9_b7 b7 top sky130_fd_pr__cap_mim_m3_1_4V3HYR
XC6_15_b7 b7 top sky130_fd_pr__cap_mim_m3_1_4V3HYR
XC1_6_b7 b7 top sky130_fd_pr__cap_mim_m3_1_4V3HYR
XC4_3_b5 b5 top sky130_fd_pr__cap_mim_m3_1_4V3HYR
XC2_4_b7 b7 top sky130_fd_pr__cap_mim_m3_1_4V3HYR
XC3_5_b6 b6 top sky130_fd_pr__cap_mim_m3_1_4V3HYR
XC13_10_b6 b6 top sky130_fd_pr__cap_mim_m3_1_4V3HYR
XC1_9_b7 b7 top sky130_fd_pr__cap_mim_m3_1_4V3HYR
XC3_2_b7 b7 top sky130_fd_pr__cap_mim_m3_1_4V3HYR
XC5_7_b4 b4 top sky130_fd_pr__cap_mim_m3_1_4V3HYR
XC3_12_b5 b5 top sky130_fd_pr__cap_mim_m3_1_4V3HYR
XC5_15_b7 b7 top sky130_fd_pr__cap_mim_m3_1_4V3HYR
XC14_13_b7 b7 top sky130_fd_pr__cap_mim_m3_1_4V3HYR
XC4_0_b7 b7 top sky130_fd_pr__cap_mim_m3_1_4V3HYR
XC5_1_b6 b6 top sky130_fd_pr__cap_mim_m3_1_4V3HYR
XC9_8_b1 b1 top sky130_fd_pr__cap_mim_m3_1_4V3HYR
XC12_10_b6 b6 top sky130_fd_pr__cap_mim_m3_1_4V3HYR
XC13_13_b7 b7 top sky130_fd_pr__cap_mim_m3_1_4V3HYR
XC2_12_b5 b5 top sky130_fd_pr__cap_mim_m3_1_4V3HYR
XC4_15_b7 b7 top sky130_fd_pr__cap_mim_m3_1_4V3HYR
XC7_3_b5 b5 top sky130_fd_pr__cap_mim_m3_1_4V3HYR
XC4_6_b7 b7 top sky130_fd_pr__cap_mim_m3_1_4V3HYR
XC5_4_b7 b7 top sky130_fd_pr__cap_mim_m3_1_4V3HYR
XC6_5_b6 b6 top sky130_fd_pr__cap_mim_m3_1_4V3HYR
XC4_9_b7 b7 top sky130_fd_pr__cap_mim_m3_1_4V3HYR
XC11_10_b6 b6 top sky130_fd_pr__cap_mim_m3_1_4V3HYR
XC8_7_b4 b4 top sky130_fd_pr__cap_mim_m3_1_4V3HYR
XC6_2_b7 b7 top sky130_fd_pr__cap_mim_m3_1_4V3HYR
XC1_12_b5 b5 top sky130_fd_pr__cap_mim_m3_1_4V3HYR
XC3_15_b7 b7 top sky130_fd_pr__cap_mim_m3_1_4V3HYR
XC12_13_b7 b7 top sky130_fd_pr__cap_mim_m3_1_4V3HYR
XC7_0_b7 b7 top sky130_fd_pr__cap_mim_m3_1_4V3HYR
XC8_1_b6 b6 top sky130_fd_pr__cap_mim_m3_1_4V3HYR
XC10_10_b6 b6 top sky130_fd_pr__cap_mim_m3_1_4V3HYR
XC11_8_b2 b2 top sky130_fd_pr__cap_mim_m3_1_4V3HYR
XC11_13_b7 b7 top sky130_fd_pr__cap_mim_m3_1_4V3HYR
XC0_12_b5 b5 top sky130_fd_pr__cap_mim_m3_1_4V3HYR
XC2_15_b7 b7 top sky130_fd_pr__cap_mim_m3_1_4V3HYR
XC7_6_b7 b7 top sky130_fd_pr__cap_mim_m3_1_4V3HYR
XC10_7_b4 b4 top sky130_fd_pr__cap_mim_m3_1_4V3HYR
XC9_10_b6 b6 top sky130_fd_pr__cap_mim_m3_1_4V3HYR
XC9_5_b6 b6 top sky130_fd_pr__cap_mim_m3_1_4V3HYR
XC8_4_b7 b7 top sky130_fd_pr__cap_mim_m3_1_4V3HYR
XC9_2_b7 b7 top sky130_fd_pr__cap_mim_m3_1_4V3HYR
XC7_9_b7 b7 top sky130_fd_pr__cap_mim_m3_1_4V3HYR
XC10_13_b7 b7 top sky130_fd_pr__cap_mim_m3_1_4V3HYR
XC10_1_b6 b6 top sky130_fd_pr__cap_mim_m3_1_4V3HYR
XC1_15_b7 b7 top sky130_fd_pr__cap_mim_m3_1_4V3HYR
XC8_10_b6 b6 top sky130_fd_pr__cap_mim_m3_1_4V3HYR
.ends
