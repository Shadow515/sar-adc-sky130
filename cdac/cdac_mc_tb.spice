* CDAC mismatch test: bits switch on one after another
.lib /foss/pdks/sky130A/libs.tech/ngspice/sky130.lib.spice tt_mm
.include cdac_units.spice
Xdac top b0 b1 b2 b3 b4 b5 b6 b7 bd cdac_units
Rleak top vcm 1e15
Vcm vcm 0 0.9
Vd bd 0 0
V0 b0 0 pwl(0 0 1n 0 1.1n 1.8)
V1 b1 0 pwl(0 0 2n 0 2.1n 1.8)
V2 b2 0 pwl(0 0 3n 0 3.1n 1.8)
V3 b3 0 pwl(0 0 4n 0 4.1n 1.8)
V4 b4 0 pwl(0 0 5n 0 5.1n 1.8)
V5 b5 0 pwl(0 0 6n 0 6.1n 1.8)
V6 b6 0 pwl(0 0 7n 0 7.1n 1.8)
V7 b7 0 pwl(0 0 8n 0 8.1n 1.8)
.ic v(top)=0.9
.control
tran 20p 9n uic
meas tran v0 find v(top) at=0.5n
meas tran v1 find v(top) at=1.5n
meas tran v2 find v(top) at=2.5n
meas tran v3 find v(top) at=3.5n
meas tran v4 find v(top) at=4.5n
meas tran v5 find v(top) at=5.5n
meas tran v6 find v(top) at=6.5n
meas tran v7 find v(top) at=7.5n
meas tran v8 find v(top) at=8.5n
.endc
.end
