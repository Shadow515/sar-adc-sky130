* 8-bit CDAC from individual unit caps (for mismatch)
.subckt cdac_units top b0 b1 b2 b3 b4 b5 b6 b7 bd
XCd top bd sky130_fd_pr__cap_mim_m3_1 W=2 L=2 MF=1 m=1
XC0_1 top b0 sky130_fd_pr__cap_mim_m3_1 W=2 L=2 MF=1 m=1
XC1_1 top b1 sky130_fd_pr__cap_mim_m3_1 W=2 L=2 MF=1 m=1
XC1_2 top b1 sky130_fd_pr__cap_mim_m3_1 W=2 L=2 MF=1 m=1
XC2_1 top b2 sky130_fd_pr__cap_mim_m3_1 W=2 L=2 MF=1 m=1
XC2_2 top b2 sky130_fd_pr__cap_mim_m3_1 W=2 L=2 MF=1 m=1
XC2_3 top b2 sky130_fd_pr__cap_mim_m3_1 W=2 L=2 MF=1 m=1
XC2_4 top b2 sky130_fd_pr__cap_mim_m3_1 W=2 L=2 MF=1 m=1
XC3_1 top b3 sky130_fd_pr__cap_mim_m3_1 W=2 L=2 MF=1 m=1
XC3_2 top b3 sky130_fd_pr__cap_mim_m3_1 W=2 L=2 MF=1 m=1
XC3_3 top b3 sky130_fd_pr__cap_mim_m3_1 W=2 L=2 MF=1 m=1
XC3_4 top b3 sky130_fd_pr__cap_mim_m3_1 W=2 L=2 MF=1 m=1
XC3_5 top b3 sky130_fd_pr__cap_mim_m3_1 W=2 L=2 MF=1 m=1
XC3_6 top b3 sky130_fd_pr__cap_mim_m3_1 W=2 L=2 MF=1 m=1
XC3_7 top b3 sky130_fd_pr__cap_mim_m3_1 W=2 L=2 MF=1 m=1
XC3_8 top b3 sky130_fd_pr__cap_mim_m3_1 W=2 L=2 MF=1 m=1
XC4_1 top b4 sky130_fd_pr__cap_mim_m3_1 W=2 L=2 MF=1 m=1
XC4_2 top b4 sky130_fd_pr__cap_mim_m3_1 W=2 L=2 MF=1 m=1
XC4_3 top b4 sky130_fd_pr__cap_mim_m3_1 W=2 L=2 MF=1 m=1
XC4_4 top b4 sky130_fd_pr__cap_mim_m3_1 W=2 L=2 MF=1 m=1
XC4_5 top b4 sky130_fd_pr__cap_mim_m3_1 W=2 L=2 MF=1 m=1
XC4_6 top b4 sky130_fd_pr__cap_mim_m3_1 W=2 L=2 MF=1 m=1
XC4_7 top b4 sky130_fd_pr__cap_mim_m3_1 W=2 L=2 MF=1 m=1
XC4_8 top b4 sky130_fd_pr__cap_mim_m3_1 W=2 L=2 MF=1 m=1
XC4_9 top b4 sky130_fd_pr__cap_mim_m3_1 W=2 L=2 MF=1 m=1
XC4_10 top b4 sky130_fd_pr__cap_mim_m3_1 W=2 L=2 MF=1 m=1
XC4_11 top b4 sky130_fd_pr__cap_mim_m3_1 W=2 L=2 MF=1 m=1
XC4_12 top b4 sky130_fd_pr__cap_mim_m3_1 W=2 L=2 MF=1 m=1
XC4_13 top b4 sky130_fd_pr__cap_mim_m3_1 W=2 L=2 MF=1 m=1
XC4_14 top b4 sky130_fd_pr__cap_mim_m3_1 W=2 L=2 MF=1 m=1
XC4_15 top b4 sky130_fd_pr__cap_mim_m3_1 W=2 L=2 MF=1 m=1
XC4_16 top b4 sky130_fd_pr__cap_mim_m3_1 W=2 L=2 MF=1 m=1
XC5_1 top b5 sky130_fd_pr__cap_mim_m3_1 W=2 L=2 MF=1 m=1
XC5_2 top b5 sky130_fd_pr__cap_mim_m3_1 W=2 L=2 MF=1 m=1
XC5_3 top b5 sky130_fd_pr__cap_mim_m3_1 W=2 L=2 MF=1 m=1
XC5_4 top b5 sky130_fd_pr__cap_mim_m3_1 W=2 L=2 MF=1 m=1
XC5_5 top b5 sky130_fd_pr__cap_mim_m3_1 W=2 L=2 MF=1 m=1
XC5_6 top b5 sky130_fd_pr__cap_mim_m3_1 W=2 L=2 MF=1 m=1
XC5_7 top b5 sky130_fd_pr__cap_mim_m3_1 W=2 L=2 MF=1 m=1
XC5_8 top b5 sky130_fd_pr__cap_mim_m3_1 W=2 L=2 MF=1 m=1
XC5_9 top b5 sky130_fd_pr__cap_mim_m3_1 W=2 L=2 MF=1 m=1
XC5_10 top b5 sky130_fd_pr__cap_mim_m3_1 W=2 L=2 MF=1 m=1
XC5_11 top b5 sky130_fd_pr__cap_mim_m3_1 W=2 L=2 MF=1 m=1
XC5_12 top b5 sky130_fd_pr__cap_mim_m3_1 W=2 L=2 MF=1 m=1
XC5_13 top b5 sky130_fd_pr__cap_mim_m3_1 W=2 L=2 MF=1 m=1
XC5_14 top b5 sky130_fd_pr__cap_mim_m3_1 W=2 L=2 MF=1 m=1
XC5_15 top b5 sky130_fd_pr__cap_mim_m3_1 W=2 L=2 MF=1 m=1
XC5_16 top b5 sky130_fd_pr__cap_mim_m3_1 W=2 L=2 MF=1 m=1
XC5_17 top b5 sky130_fd_pr__cap_mim_m3_1 W=2 L=2 MF=1 m=1
XC5_18 top b5 sky130_fd_pr__cap_mim_m3_1 W=2 L=2 MF=1 m=1
XC5_19 top b5 sky130_fd_pr__cap_mim_m3_1 W=2 L=2 MF=1 m=1
XC5_20 top b5 sky130_fd_pr__cap_mim_m3_1 W=2 L=2 MF=1 m=1
XC5_21 top b5 sky130_fd_pr__cap_mim_m3_1 W=2 L=2 MF=1 m=1
XC5_22 top b5 sky130_fd_pr__cap_mim_m3_1 W=2 L=2 MF=1 m=1
XC5_23 top b5 sky130_fd_pr__cap_mim_m3_1 W=2 L=2 MF=1 m=1
XC5_24 top b5 sky130_fd_pr__cap_mim_m3_1 W=2 L=2 MF=1 m=1
XC5_25 top b5 sky130_fd_pr__cap_mim_m3_1 W=2 L=2 MF=1 m=1
XC5_26 top b5 sky130_fd_pr__cap_mim_m3_1 W=2 L=2 MF=1 m=1
XC5_27 top b5 sky130_fd_pr__cap_mim_m3_1 W=2 L=2 MF=1 m=1
XC5_28 top b5 sky130_fd_pr__cap_mim_m3_1 W=2 L=2 MF=1 m=1
XC5_29 top b5 sky130_fd_pr__cap_mim_m3_1 W=2 L=2 MF=1 m=1
XC5_30 top b5 sky130_fd_pr__cap_mim_m3_1 W=2 L=2 MF=1 m=1
XC5_31 top b5 sky130_fd_pr__cap_mim_m3_1 W=2 L=2 MF=1 m=1
XC5_32 top b5 sky130_fd_pr__cap_mim_m3_1 W=2 L=2 MF=1 m=1
XC6_1 top b6 sky130_fd_pr__cap_mim_m3_1 W=2 L=2 MF=1 m=1
XC6_2 top b6 sky130_fd_pr__cap_mim_m3_1 W=2 L=2 MF=1 m=1
XC6_3 top b6 sky130_fd_pr__cap_mim_m3_1 W=2 L=2 MF=1 m=1
XC6_4 top b6 sky130_fd_pr__cap_mim_m3_1 W=2 L=2 MF=1 m=1
XC6_5 top b6 sky130_fd_pr__cap_mim_m3_1 W=2 L=2 MF=1 m=1
XC6_6 top b6 sky130_fd_pr__cap_mim_m3_1 W=2 L=2 MF=1 m=1
XC6_7 top b6 sky130_fd_pr__cap_mim_m3_1 W=2 L=2 MF=1 m=1
XC6_8 top b6 sky130_fd_pr__cap_mim_m3_1 W=2 L=2 MF=1 m=1
XC6_9 top b6 sky130_fd_pr__cap_mim_m3_1 W=2 L=2 MF=1 m=1
XC6_10 top b6 sky130_fd_pr__cap_mim_m3_1 W=2 L=2 MF=1 m=1
XC6_11 top b6 sky130_fd_pr__cap_mim_m3_1 W=2 L=2 MF=1 m=1
XC6_12 top b6 sky130_fd_pr__cap_mim_m3_1 W=2 L=2 MF=1 m=1
XC6_13 top b6 sky130_fd_pr__cap_mim_m3_1 W=2 L=2 MF=1 m=1
XC6_14 top b6 sky130_fd_pr__cap_mim_m3_1 W=2 L=2 MF=1 m=1
XC6_15 top b6 sky130_fd_pr__cap_mim_m3_1 W=2 L=2 MF=1 m=1
XC6_16 top b6 sky130_fd_pr__cap_mim_m3_1 W=2 L=2 MF=1 m=1
XC6_17 top b6 sky130_fd_pr__cap_mim_m3_1 W=2 L=2 MF=1 m=1
XC6_18 top b6 sky130_fd_pr__cap_mim_m3_1 W=2 L=2 MF=1 m=1
XC6_19 top b6 sky130_fd_pr__cap_mim_m3_1 W=2 L=2 MF=1 m=1
XC6_20 top b6 sky130_fd_pr__cap_mim_m3_1 W=2 L=2 MF=1 m=1
XC6_21 top b6 sky130_fd_pr__cap_mim_m3_1 W=2 L=2 MF=1 m=1
XC6_22 top b6 sky130_fd_pr__cap_mim_m3_1 W=2 L=2 MF=1 m=1
XC6_23 top b6 sky130_fd_pr__cap_mim_m3_1 W=2 L=2 MF=1 m=1
XC6_24 top b6 sky130_fd_pr__cap_mim_m3_1 W=2 L=2 MF=1 m=1
XC6_25 top b6 sky130_fd_pr__cap_mim_m3_1 W=2 L=2 MF=1 m=1
XC6_26 top b6 sky130_fd_pr__cap_mim_m3_1 W=2 L=2 MF=1 m=1
XC6_27 top b6 sky130_fd_pr__cap_mim_m3_1 W=2 L=2 MF=1 m=1
XC6_28 top b6 sky130_fd_pr__cap_mim_m3_1 W=2 L=2 MF=1 m=1
XC6_29 top b6 sky130_fd_pr__cap_mim_m3_1 W=2 L=2 MF=1 m=1
XC6_30 top b6 sky130_fd_pr__cap_mim_m3_1 W=2 L=2 MF=1 m=1
XC6_31 top b6 sky130_fd_pr__cap_mim_m3_1 W=2 L=2 MF=1 m=1
XC6_32 top b6 sky130_fd_pr__cap_mim_m3_1 W=2 L=2 MF=1 m=1
XC6_33 top b6 sky130_fd_pr__cap_mim_m3_1 W=2 L=2 MF=1 m=1
XC6_34 top b6 sky130_fd_pr__cap_mim_m3_1 W=2 L=2 MF=1 m=1
XC6_35 top b6 sky130_fd_pr__cap_mim_m3_1 W=2 L=2 MF=1 m=1
XC6_36 top b6 sky130_fd_pr__cap_mim_m3_1 W=2 L=2 MF=1 m=1
XC6_37 top b6 sky130_fd_pr__cap_mim_m3_1 W=2 L=2 MF=1 m=1
XC6_38 top b6 sky130_fd_pr__cap_mim_m3_1 W=2 L=2 MF=1 m=1
XC6_39 top b6 sky130_fd_pr__cap_mim_m3_1 W=2 L=2 MF=1 m=1
XC6_40 top b6 sky130_fd_pr__cap_mim_m3_1 W=2 L=2 MF=1 m=1
XC6_41 top b6 sky130_fd_pr__cap_mim_m3_1 W=2 L=2 MF=1 m=1
XC6_42 top b6 sky130_fd_pr__cap_mim_m3_1 W=2 L=2 MF=1 m=1
XC6_43 top b6 sky130_fd_pr__cap_mim_m3_1 W=2 L=2 MF=1 m=1
XC6_44 top b6 sky130_fd_pr__cap_mim_m3_1 W=2 L=2 MF=1 m=1
XC6_45 top b6 sky130_fd_pr__cap_mim_m3_1 W=2 L=2 MF=1 m=1
XC6_46 top b6 sky130_fd_pr__cap_mim_m3_1 W=2 L=2 MF=1 m=1
XC6_47 top b6 sky130_fd_pr__cap_mim_m3_1 W=2 L=2 MF=1 m=1
XC6_48 top b6 sky130_fd_pr__cap_mim_m3_1 W=2 L=2 MF=1 m=1
XC6_49 top b6 sky130_fd_pr__cap_mim_m3_1 W=2 L=2 MF=1 m=1
XC6_50 top b6 sky130_fd_pr__cap_mim_m3_1 W=2 L=2 MF=1 m=1
XC6_51 top b6 sky130_fd_pr__cap_mim_m3_1 W=2 L=2 MF=1 m=1
XC6_52 top b6 sky130_fd_pr__cap_mim_m3_1 W=2 L=2 MF=1 m=1
XC6_53 top b6 sky130_fd_pr__cap_mim_m3_1 W=2 L=2 MF=1 m=1
XC6_54 top b6 sky130_fd_pr__cap_mim_m3_1 W=2 L=2 MF=1 m=1
XC6_55 top b6 sky130_fd_pr__cap_mim_m3_1 W=2 L=2 MF=1 m=1
XC6_56 top b6 sky130_fd_pr__cap_mim_m3_1 W=2 L=2 MF=1 m=1
XC6_57 top b6 sky130_fd_pr__cap_mim_m3_1 W=2 L=2 MF=1 m=1
XC6_58 top b6 sky130_fd_pr__cap_mim_m3_1 W=2 L=2 MF=1 m=1
XC6_59 top b6 sky130_fd_pr__cap_mim_m3_1 W=2 L=2 MF=1 m=1
XC6_60 top b6 sky130_fd_pr__cap_mim_m3_1 W=2 L=2 MF=1 m=1
XC6_61 top b6 sky130_fd_pr__cap_mim_m3_1 W=2 L=2 MF=1 m=1
XC6_62 top b6 sky130_fd_pr__cap_mim_m3_1 W=2 L=2 MF=1 m=1
XC6_63 top b6 sky130_fd_pr__cap_mim_m3_1 W=2 L=2 MF=1 m=1
XC6_64 top b6 sky130_fd_pr__cap_mim_m3_1 W=2 L=2 MF=1 m=1
XC7_1 top b7 sky130_fd_pr__cap_mim_m3_1 W=2 L=2 MF=1 m=1
XC7_2 top b7 sky130_fd_pr__cap_mim_m3_1 W=2 L=2 MF=1 m=1
XC7_3 top b7 sky130_fd_pr__cap_mim_m3_1 W=2 L=2 MF=1 m=1
XC7_4 top b7 sky130_fd_pr__cap_mim_m3_1 W=2 L=2 MF=1 m=1
XC7_5 top b7 sky130_fd_pr__cap_mim_m3_1 W=2 L=2 MF=1 m=1
XC7_6 top b7 sky130_fd_pr__cap_mim_m3_1 W=2 L=2 MF=1 m=1
XC7_7 top b7 sky130_fd_pr__cap_mim_m3_1 W=2 L=2 MF=1 m=1
XC7_8 top b7 sky130_fd_pr__cap_mim_m3_1 W=2 L=2 MF=1 m=1
XC7_9 top b7 sky130_fd_pr__cap_mim_m3_1 W=2 L=2 MF=1 m=1
XC7_10 top b7 sky130_fd_pr__cap_mim_m3_1 W=2 L=2 MF=1 m=1
XC7_11 top b7 sky130_fd_pr__cap_mim_m3_1 W=2 L=2 MF=1 m=1
XC7_12 top b7 sky130_fd_pr__cap_mim_m3_1 W=2 L=2 MF=1 m=1
XC7_13 top b7 sky130_fd_pr__cap_mim_m3_1 W=2 L=2 MF=1 m=1
XC7_14 top b7 sky130_fd_pr__cap_mim_m3_1 W=2 L=2 MF=1 m=1
XC7_15 top b7 sky130_fd_pr__cap_mim_m3_1 W=2 L=2 MF=1 m=1
XC7_16 top b7 sky130_fd_pr__cap_mim_m3_1 W=2 L=2 MF=1 m=1
XC7_17 top b7 sky130_fd_pr__cap_mim_m3_1 W=2 L=2 MF=1 m=1
XC7_18 top b7 sky130_fd_pr__cap_mim_m3_1 W=2 L=2 MF=1 m=1
XC7_19 top b7 sky130_fd_pr__cap_mim_m3_1 W=2 L=2 MF=1 m=1
XC7_20 top b7 sky130_fd_pr__cap_mim_m3_1 W=2 L=2 MF=1 m=1
XC7_21 top b7 sky130_fd_pr__cap_mim_m3_1 W=2 L=2 MF=1 m=1
XC7_22 top b7 sky130_fd_pr__cap_mim_m3_1 W=2 L=2 MF=1 m=1
XC7_23 top b7 sky130_fd_pr__cap_mim_m3_1 W=2 L=2 MF=1 m=1
XC7_24 top b7 sky130_fd_pr__cap_mim_m3_1 W=2 L=2 MF=1 m=1
XC7_25 top b7 sky130_fd_pr__cap_mim_m3_1 W=2 L=2 MF=1 m=1
XC7_26 top b7 sky130_fd_pr__cap_mim_m3_1 W=2 L=2 MF=1 m=1
XC7_27 top b7 sky130_fd_pr__cap_mim_m3_1 W=2 L=2 MF=1 m=1
XC7_28 top b7 sky130_fd_pr__cap_mim_m3_1 W=2 L=2 MF=1 m=1
XC7_29 top b7 sky130_fd_pr__cap_mim_m3_1 W=2 L=2 MF=1 m=1
XC7_30 top b7 sky130_fd_pr__cap_mim_m3_1 W=2 L=2 MF=1 m=1
XC7_31 top b7 sky130_fd_pr__cap_mim_m3_1 W=2 L=2 MF=1 m=1
XC7_32 top b7 sky130_fd_pr__cap_mim_m3_1 W=2 L=2 MF=1 m=1
XC7_33 top b7 sky130_fd_pr__cap_mim_m3_1 W=2 L=2 MF=1 m=1
XC7_34 top b7 sky130_fd_pr__cap_mim_m3_1 W=2 L=2 MF=1 m=1
XC7_35 top b7 sky130_fd_pr__cap_mim_m3_1 W=2 L=2 MF=1 m=1
XC7_36 top b7 sky130_fd_pr__cap_mim_m3_1 W=2 L=2 MF=1 m=1
XC7_37 top b7 sky130_fd_pr__cap_mim_m3_1 W=2 L=2 MF=1 m=1
XC7_38 top b7 sky130_fd_pr__cap_mim_m3_1 W=2 L=2 MF=1 m=1
XC7_39 top b7 sky130_fd_pr__cap_mim_m3_1 W=2 L=2 MF=1 m=1
XC7_40 top b7 sky130_fd_pr__cap_mim_m3_1 W=2 L=2 MF=1 m=1
XC7_41 top b7 sky130_fd_pr__cap_mim_m3_1 W=2 L=2 MF=1 m=1
XC7_42 top b7 sky130_fd_pr__cap_mim_m3_1 W=2 L=2 MF=1 m=1
XC7_43 top b7 sky130_fd_pr__cap_mim_m3_1 W=2 L=2 MF=1 m=1
XC7_44 top b7 sky130_fd_pr__cap_mim_m3_1 W=2 L=2 MF=1 m=1
XC7_45 top b7 sky130_fd_pr__cap_mim_m3_1 W=2 L=2 MF=1 m=1
XC7_46 top b7 sky130_fd_pr__cap_mim_m3_1 W=2 L=2 MF=1 m=1
XC7_47 top b7 sky130_fd_pr__cap_mim_m3_1 W=2 L=2 MF=1 m=1
XC7_48 top b7 sky130_fd_pr__cap_mim_m3_1 W=2 L=2 MF=1 m=1
XC7_49 top b7 sky130_fd_pr__cap_mim_m3_1 W=2 L=2 MF=1 m=1
XC7_50 top b7 sky130_fd_pr__cap_mim_m3_1 W=2 L=2 MF=1 m=1
XC7_51 top b7 sky130_fd_pr__cap_mim_m3_1 W=2 L=2 MF=1 m=1
XC7_52 top b7 sky130_fd_pr__cap_mim_m3_1 W=2 L=2 MF=1 m=1
XC7_53 top b7 sky130_fd_pr__cap_mim_m3_1 W=2 L=2 MF=1 m=1
XC7_54 top b7 sky130_fd_pr__cap_mim_m3_1 W=2 L=2 MF=1 m=1
XC7_55 top b7 sky130_fd_pr__cap_mim_m3_1 W=2 L=2 MF=1 m=1
XC7_56 top b7 sky130_fd_pr__cap_mim_m3_1 W=2 L=2 MF=1 m=1
XC7_57 top b7 sky130_fd_pr__cap_mim_m3_1 W=2 L=2 MF=1 m=1
XC7_58 top b7 sky130_fd_pr__cap_mim_m3_1 W=2 L=2 MF=1 m=1
XC7_59 top b7 sky130_fd_pr__cap_mim_m3_1 W=2 L=2 MF=1 m=1
XC7_60 top b7 sky130_fd_pr__cap_mim_m3_1 W=2 L=2 MF=1 m=1
XC7_61 top b7 sky130_fd_pr__cap_mim_m3_1 W=2 L=2 MF=1 m=1
XC7_62 top b7 sky130_fd_pr__cap_mim_m3_1 W=2 L=2 MF=1 m=1
XC7_63 top b7 sky130_fd_pr__cap_mim_m3_1 W=2 L=2 MF=1 m=1
XC7_64 top b7 sky130_fd_pr__cap_mim_m3_1 W=2 L=2 MF=1 m=1
XC7_65 top b7 sky130_fd_pr__cap_mim_m3_1 W=2 L=2 MF=1 m=1
XC7_66 top b7 sky130_fd_pr__cap_mim_m3_1 W=2 L=2 MF=1 m=1
XC7_67 top b7 sky130_fd_pr__cap_mim_m3_1 W=2 L=2 MF=1 m=1
XC7_68 top b7 sky130_fd_pr__cap_mim_m3_1 W=2 L=2 MF=1 m=1
XC7_69 top b7 sky130_fd_pr__cap_mim_m3_1 W=2 L=2 MF=1 m=1
XC7_70 top b7 sky130_fd_pr__cap_mim_m3_1 W=2 L=2 MF=1 m=1
XC7_71 top b7 sky130_fd_pr__cap_mim_m3_1 W=2 L=2 MF=1 m=1
XC7_72 top b7 sky130_fd_pr__cap_mim_m3_1 W=2 L=2 MF=1 m=1
XC7_73 top b7 sky130_fd_pr__cap_mim_m3_1 W=2 L=2 MF=1 m=1
XC7_74 top b7 sky130_fd_pr__cap_mim_m3_1 W=2 L=2 MF=1 m=1
XC7_75 top b7 sky130_fd_pr__cap_mim_m3_1 W=2 L=2 MF=1 m=1
XC7_76 top b7 sky130_fd_pr__cap_mim_m3_1 W=2 L=2 MF=1 m=1
XC7_77 top b7 sky130_fd_pr__cap_mim_m3_1 W=2 L=2 MF=1 m=1
XC7_78 top b7 sky130_fd_pr__cap_mim_m3_1 W=2 L=2 MF=1 m=1
XC7_79 top b7 sky130_fd_pr__cap_mim_m3_1 W=2 L=2 MF=1 m=1
XC7_80 top b7 sky130_fd_pr__cap_mim_m3_1 W=2 L=2 MF=1 m=1
XC7_81 top b7 sky130_fd_pr__cap_mim_m3_1 W=2 L=2 MF=1 m=1
XC7_82 top b7 sky130_fd_pr__cap_mim_m3_1 W=2 L=2 MF=1 m=1
XC7_83 top b7 sky130_fd_pr__cap_mim_m3_1 W=2 L=2 MF=1 m=1
XC7_84 top b7 sky130_fd_pr__cap_mim_m3_1 W=2 L=2 MF=1 m=1
XC7_85 top b7 sky130_fd_pr__cap_mim_m3_1 W=2 L=2 MF=1 m=1
XC7_86 top b7 sky130_fd_pr__cap_mim_m3_1 W=2 L=2 MF=1 m=1
XC7_87 top b7 sky130_fd_pr__cap_mim_m3_1 W=2 L=2 MF=1 m=1
XC7_88 top b7 sky130_fd_pr__cap_mim_m3_1 W=2 L=2 MF=1 m=1
XC7_89 top b7 sky130_fd_pr__cap_mim_m3_1 W=2 L=2 MF=1 m=1
XC7_90 top b7 sky130_fd_pr__cap_mim_m3_1 W=2 L=2 MF=1 m=1
XC7_91 top b7 sky130_fd_pr__cap_mim_m3_1 W=2 L=2 MF=1 m=1
XC7_92 top b7 sky130_fd_pr__cap_mim_m3_1 W=2 L=2 MF=1 m=1
XC7_93 top b7 sky130_fd_pr__cap_mim_m3_1 W=2 L=2 MF=1 m=1
XC7_94 top b7 sky130_fd_pr__cap_mim_m3_1 W=2 L=2 MF=1 m=1
XC7_95 top b7 sky130_fd_pr__cap_mim_m3_1 W=2 L=2 MF=1 m=1
XC7_96 top b7 sky130_fd_pr__cap_mim_m3_1 W=2 L=2 MF=1 m=1
XC7_97 top b7 sky130_fd_pr__cap_mim_m3_1 W=2 L=2 MF=1 m=1
XC7_98 top b7 sky130_fd_pr__cap_mim_m3_1 W=2 L=2 MF=1 m=1
XC7_99 top b7 sky130_fd_pr__cap_mim_m3_1 W=2 L=2 MF=1 m=1
XC7_100 top b7 sky130_fd_pr__cap_mim_m3_1 W=2 L=2 MF=1 m=1
XC7_101 top b7 sky130_fd_pr__cap_mim_m3_1 W=2 L=2 MF=1 m=1
XC7_102 top b7 sky130_fd_pr__cap_mim_m3_1 W=2 L=2 MF=1 m=1
XC7_103 top b7 sky130_fd_pr__cap_mim_m3_1 W=2 L=2 MF=1 m=1
XC7_104 top b7 sky130_fd_pr__cap_mim_m3_1 W=2 L=2 MF=1 m=1
XC7_105 top b7 sky130_fd_pr__cap_mim_m3_1 W=2 L=2 MF=1 m=1
XC7_106 top b7 sky130_fd_pr__cap_mim_m3_1 W=2 L=2 MF=1 m=1
XC7_107 top b7 sky130_fd_pr__cap_mim_m3_1 W=2 L=2 MF=1 m=1
XC7_108 top b7 sky130_fd_pr__cap_mim_m3_1 W=2 L=2 MF=1 m=1
XC7_109 top b7 sky130_fd_pr__cap_mim_m3_1 W=2 L=2 MF=1 m=1
XC7_110 top b7 sky130_fd_pr__cap_mim_m3_1 W=2 L=2 MF=1 m=1
XC7_111 top b7 sky130_fd_pr__cap_mim_m3_1 W=2 L=2 MF=1 m=1
XC7_112 top b7 sky130_fd_pr__cap_mim_m3_1 W=2 L=2 MF=1 m=1
XC7_113 top b7 sky130_fd_pr__cap_mim_m3_1 W=2 L=2 MF=1 m=1
XC7_114 top b7 sky130_fd_pr__cap_mim_m3_1 W=2 L=2 MF=1 m=1
XC7_115 top b7 sky130_fd_pr__cap_mim_m3_1 W=2 L=2 MF=1 m=1
XC7_116 top b7 sky130_fd_pr__cap_mim_m3_1 W=2 L=2 MF=1 m=1
XC7_117 top b7 sky130_fd_pr__cap_mim_m3_1 W=2 L=2 MF=1 m=1
XC7_118 top b7 sky130_fd_pr__cap_mim_m3_1 W=2 L=2 MF=1 m=1
XC7_119 top b7 sky130_fd_pr__cap_mim_m3_1 W=2 L=2 MF=1 m=1
XC7_120 top b7 sky130_fd_pr__cap_mim_m3_1 W=2 L=2 MF=1 m=1
XC7_121 top b7 sky130_fd_pr__cap_mim_m3_1 W=2 L=2 MF=1 m=1
XC7_122 top b7 sky130_fd_pr__cap_mim_m3_1 W=2 L=2 MF=1 m=1
XC7_123 top b7 sky130_fd_pr__cap_mim_m3_1 W=2 L=2 MF=1 m=1
XC7_124 top b7 sky130_fd_pr__cap_mim_m3_1 W=2 L=2 MF=1 m=1
XC7_125 top b7 sky130_fd_pr__cap_mim_m3_1 W=2 L=2 MF=1 m=1
XC7_126 top b7 sky130_fd_pr__cap_mim_m3_1 W=2 L=2 MF=1 m=1
XC7_127 top b7 sky130_fd_pr__cap_mim_m3_1 W=2 L=2 MF=1 m=1
XC7_128 top b7 sky130_fd_pr__cap_mim_m3_1 W=2 L=2 MF=1 m=1
.ends
