* NGSPICE file created from adc_top.ext - technology: sky130A

.subckt sky130_fd_sc_hd__decap_3 VPWR VGND VPB VNB
X0 VPWR VGND VPWR VPB sky130_fd_pr__pfet_01v8_hvt ad=0.2262 pd=2.26 as=0.4524 ps=4.52 w=0.87 l=0.59
X1 VGND VPWR VGND VNB sky130_fd_pr__nfet_01v8 ad=0.143 pd=1.62 as=0.286 ps=3.24 w=0.55 l=0.59
.ends

.subckt sky130_fd_sc_hd__decap_12 VGND VPWR VPB VNB
X0 VPWR VGND VPWR VPB sky130_fd_pr__pfet_01v8_hvt ad=0.2262 pd=2.26 as=0.4524 ps=4.52 w=0.87 l=4.73
X1 VGND VPWR VGND VNB sky130_fd_pr__nfet_01v8 ad=0.143 pd=1.62 as=0.286 ps=3.24 w=0.55 l=4.73
.ends

.subckt sky130_fd_sc_hd__dfrtp_1 VGND VPWR VPB VNB CLK D RESET_B Q
X0 a_805_47# a_761_289# a_639_47# VNB sky130_fd_pr__nfet_01v8 ad=0.0441 pd=0.63 as=0.1401 ps=1.1 w=0.42 l=0.15
X1 a_1217_47# a_27_47# a_1108_47# VNB sky130_fd_pr__special_nfet_01v8 ad=0.0669 pd=0.75 as=0.0711 ps=0.755 w=0.36 l=0.15
X2 a_1283_21# a_1108_47# a_1462_47# VNB sky130_fd_pr__nfet_01v8 ad=0.1092 pd=1.36 as=0.06405 ps=0.725 w=0.42 l=0.15
X3 a_651_413# a_27_47# a_543_47# VPB sky130_fd_pr__pfet_01v8_hvt ad=0.1155 pd=0.97 as=0.07245 ps=0.765 w=0.42 l=0.15
X4 a_1108_47# a_193_47# a_761_289# VNB sky130_fd_pr__special_nfet_01v8 ad=0.0711 pd=0.755 as=0.0999 ps=0.985 w=0.36 l=0.15
X5 VGND RESET_B a_805_47# VNB sky130_fd_pr__nfet_01v8 ad=0.1346 pd=1.15 as=0.0441 ps=0.63 w=0.42 l=0.15
X6 Q a_1283_21# VPWR VPB sky130_fd_pr__pfet_01v8_hvt ad=0.26 pd=2.52 as=0.3012 ps=2.66 w=1 l=0.15
X7 VPWR CLK a_27_47# VPB sky130_fd_pr__pfet_01v8_hvt ad=0.0864 pd=0.91 as=0.1664 ps=1.8 w=0.64 l=0.15
X8 a_448_47# D VPWR VPB sky130_fd_pr__pfet_01v8_hvt ad=0.0651 pd=0.73 as=0.1092 ps=1.36 w=0.42 l=0.15
X9 a_761_289# a_543_47# VGND VNB sky130_fd_pr__nfet_01v8 ad=0.0999 pd=0.985 as=0.1346 ps=1.15 w=0.64 l=0.15
X10 a_193_47# a_27_47# VGND VNB sky130_fd_pr__nfet_01v8 ad=0.1092 pd=1.36 as=0.0567 ps=0.69 w=0.42 l=0.15
X11 a_1108_47# a_27_47# a_761_289# VPB sky130_fd_pr__pfet_01v8_hvt ad=0.0588 pd=0.7 as=0.12915 ps=1.185 w=0.42 l=0.15
X12 a_1462_47# RESET_B VGND VNB sky130_fd_pr__nfet_01v8 ad=0.06405 pd=0.725 as=0.12495 ps=1.015 w=0.42 l=0.15
X13 a_543_47# a_27_47# a_448_47# VNB sky130_fd_pr__special_nfet_01v8 ad=0.0594 pd=0.69 as=0.066 ps=0.745 w=0.36 l=0.15
X14 a_543_47# a_193_47# a_448_47# VPB sky130_fd_pr__pfet_01v8_hvt ad=0.07245 pd=0.765 as=0.0651 ps=0.73 w=0.42 l=0.15
X15 a_448_47# D VGND VNB sky130_fd_pr__nfet_01v8 ad=0.066 pd=0.745 as=0.2205 ps=1.89 w=0.42 l=0.15
X16 VPWR a_1283_21# a_1270_413# VPB sky130_fd_pr__pfet_01v8_hvt ad=0.0819 pd=0.81 as=0.0567 ps=0.69 w=0.42 l=0.15
X17 VPWR a_1108_47# a_1283_21# VPB sky130_fd_pr__pfet_01v8_hvt ad=0.1134 pd=1.38 as=0.0567 ps=0.69 w=0.42 l=0.15
X18 a_1270_413# a_193_47# a_1108_47# VPB sky130_fd_pr__pfet_01v8_hvt ad=0.0567 pd=0.69 as=0.0588 ps=0.7 w=0.42 l=0.15
X19 a_193_47# a_27_47# VPWR VPB sky130_fd_pr__pfet_01v8_hvt ad=0.1664 pd=1.8 as=0.0864 ps=0.91 w=0.64 l=0.15
X20 a_1283_21# RESET_B VPWR VPB sky130_fd_pr__pfet_01v8_hvt ad=0.0567 pd=0.69 as=0.0819 ps=0.81 w=0.42 l=0.15
X21 VPWR a_761_289# a_651_413# VPB sky130_fd_pr__pfet_01v8_hvt ad=0.07035 pd=0.755 as=0.1155 ps=0.97 w=0.42 l=0.15
X22 Q a_1283_21# VGND VNB sky130_fd_pr__nfet_01v8 ad=0.169 pd=1.82 as=0.2087 ps=2.02 w=0.65 l=0.15
X23 a_639_47# a_193_47# a_543_47# VNB sky130_fd_pr__special_nfet_01v8 ad=0.1401 pd=1.1 as=0.0594 ps=0.69 w=0.36 l=0.15
X24 VGND a_1283_21# a_1217_47# VNB sky130_fd_pr__nfet_01v8 ad=0.12495 pd=1.015 as=0.0669 ps=0.75 w=0.42 l=0.15
X25 a_651_413# RESET_B VPWR VPB sky130_fd_pr__pfet_01v8_hvt ad=0.1092 pd=1.36 as=0.07035 ps=0.755 w=0.42 l=0.15
X26 VGND CLK a_27_47# VNB sky130_fd_pr__nfet_01v8 ad=0.0567 pd=0.69 as=0.1092 ps=1.36 w=0.42 l=0.15
X27 a_761_289# a_543_47# VPWR VPB sky130_fd_pr__pfet_01v8_hvt ad=0.12915 pd=1.185 as=0.2184 ps=2.2 w=0.84 l=0.15
.ends

.subckt sky130_fd_sc_hd__nand2_1 VPB VNB VGND VPWR A Y B
X0 VPWR A Y VPB sky130_fd_pr__pfet_01v8_hvt ad=0.26 pd=2.52 as=0.135 ps=1.27 w=1 l=0.15
X1 Y A a_113_47# VNB sky130_fd_pr__nfet_01v8 ad=0.169 pd=1.82 as=0.08775 ps=0.92 w=0.65 l=0.15
X2 a_113_47# B VGND VNB sky130_fd_pr__nfet_01v8 ad=0.08775 pd=0.92 as=0.169 ps=1.82 w=0.65 l=0.15
X3 Y B VPWR VPB sky130_fd_pr__pfet_01v8_hvt ad=0.135 pd=1.27 as=0.26 ps=2.52 w=1 l=0.15
.ends

.subckt sky130_fd_sc_hd__mux2_1 VGND VPWR VPB VNB X A1 S A0
X0 VPWR a_505_21# a_535_374# VPB sky130_fd_pr__pfet_01v8_hvt ad=0.0693 pd=0.75 as=0.0441 ps=0.63 w=0.42 l=0.15
X1 a_505_21# S VPWR VPB sky130_fd_pr__pfet_01v8_hvt ad=0.1176 pd=1.4 as=0.0693 ps=0.75 w=0.42 l=0.15
X2 a_218_374# S VPWR VPB sky130_fd_pr__pfet_01v8_hvt ad=0.07665 pd=0.785 as=0.15835 ps=1.395 w=0.42 l=0.15
X3 VGND a_505_21# a_439_47# VNB sky130_fd_pr__nfet_01v8 ad=0.1449 pd=1.11 as=0.0693 ps=0.75 w=0.42 l=0.15
X4 a_76_199# A0 a_218_374# VPB sky130_fd_pr__pfet_01v8_hvt ad=0.1932 pd=1.34 as=0.07665 ps=0.785 w=0.42 l=0.15
X5 a_505_21# S VGND VNB sky130_fd_pr__nfet_01v8 ad=0.1092 pd=1.36 as=0.1449 ps=1.11 w=0.42 l=0.15
X6 a_439_47# A0 a_76_199# VNB sky130_fd_pr__nfet_01v8 ad=0.0693 pd=0.75 as=0.09975 ps=0.895 w=0.42 l=0.15
X7 a_535_374# A1 a_76_199# VPB sky130_fd_pr__pfet_01v8_hvt ad=0.0441 pd=0.63 as=0.1932 ps=1.34 w=0.42 l=0.15
X8 a_76_199# A1 a_218_47# VNB sky130_fd_pr__nfet_01v8 ad=0.09975 pd=0.895 as=0.0693 ps=0.75 w=0.42 l=0.15
X9 a_218_47# S VGND VNB sky130_fd_pr__nfet_01v8 ad=0.0693 pd=0.75 as=0.11285 ps=1.045 w=0.42 l=0.15
X10 VPWR a_76_199# X VPB sky130_fd_pr__pfet_01v8_hvt ad=0.15835 pd=1.395 as=0.26 ps=2.52 w=1 l=0.15
X11 VGND a_76_199# X VNB sky130_fd_pr__nfet_01v8 ad=0.11285 pd=1.045 as=0.169 ps=1.82 w=0.65 l=0.15
.ends

.subckt sky130_fd_sc_hd__dlygate4sd3_1 X A VPB VNB VGND VPWR
X0 VPWR A a_49_47# VPB sky130_fd_pr__pfet_01v8_hvt ad=0.0567 pd=0.69 as=0.1092 ps=1.36 w=0.42 l=0.15
X1 VGND a_285_47# a_391_47# VNB sky130_fd_pr__nfet_01v8 ad=0.097 pd=0.975 as=0.1092 ps=1.36 w=0.42 l=0.5
X2 X a_391_47# VPWR VPB sky130_fd_pr__pfet_01v8_hvt ad=0.26 pd=2.52 as=0.14075 ps=1.325 w=1 l=0.15
X3 VGND A a_49_47# VNB sky130_fd_pr__nfet_01v8 ad=0.0567 pd=0.69 as=0.1092 ps=1.36 w=0.42 l=0.15
X4 VPWR a_285_47# a_391_47# VPB sky130_fd_pr__pfet_01v8_hvt ad=0.14075 pd=1.325 as=0.1092 ps=1.36 w=0.42 l=0.5
X5 a_285_47# a_49_47# VGND VNB sky130_fd_pr__nfet_01v8 ad=0.1092 pd=1.36 as=0.0567 ps=0.69 w=0.42 l=0.5
X6 a_285_47# a_49_47# VPWR VPB sky130_fd_pr__pfet_01v8_hvt ad=0.1092 pd=1.36 as=0.0567 ps=0.69 w=0.42 l=0.5
X7 X a_391_47# VGND VNB sky130_fd_pr__nfet_01v8 ad=0.169 pd=1.82 as=0.097 ps=0.975 w=0.65 l=0.15
.ends

.subckt sky130_fd_sc_hd__buf_2 VPWR VGND X A VPB VNB
X0 VPWR a_27_47# X VPB sky130_fd_pr__pfet_01v8_hvt ad=0.265 pd=2.53 as=0.135 ps=1.27 w=1 l=0.15
X1 X a_27_47# VPWR VPB sky130_fd_pr__pfet_01v8_hvt ad=0.135 pd=1.27 as=0.149 ps=1.325 w=1 l=0.15
X2 VPWR A a_27_47# VPB sky130_fd_pr__pfet_01v8_hvt ad=0.149 pd=1.325 as=0.1664 ps=1.8 w=0.64 l=0.15
X3 X a_27_47# VGND VNB sky130_fd_pr__nfet_01v8 ad=0.08775 pd=0.92 as=0.097 ps=0.975 w=0.65 l=0.15
X4 VGND a_27_47# X VNB sky130_fd_pr__nfet_01v8 ad=0.17225 pd=1.83 as=0.08775 ps=0.92 w=0.65 l=0.15
X5 VGND A a_27_47# VNB sky130_fd_pr__nfet_01v8 ad=0.097 pd=0.975 as=0.1092 ps=1.36 w=0.42 l=0.15
.ends

.subckt sky130_fd_sc_hd__decap_8 VPWR VGND VPB VNB
X0 VPWR VGND VPWR VPB sky130_fd_pr__pfet_01v8_hvt ad=0.2262 pd=2.26 as=0.4524 ps=4.52 w=0.87 l=2.89
X1 VGND VPWR VGND VNB sky130_fd_pr__nfet_01v8 ad=0.143 pd=1.62 as=0.286 ps=3.24 w=0.55 l=2.89
.ends

.subckt sky130_fd_sc_hd__decap_4 VGND VPWR VPB VNB
X0 VPWR VGND VPWR VPB sky130_fd_pr__pfet_01v8_hvt ad=0.2262 pd=2.26 as=0.4524 ps=4.52 w=0.87 l=1.05
X1 VGND VPWR VGND VNB sky130_fd_pr__nfet_01v8 ad=0.143 pd=1.62 as=0.286 ps=3.24 w=0.55 l=1.05
.ends

.subckt sky130_fd_sc_hd__nor3b_1 VPB VNB VGND VPWR C_N B Y A
X0 VGND a_91_199# Y VNB sky130_fd_pr__nfet_01v8 ad=0.08775 pd=0.92 as=0.221 ps=1.98 w=0.65 l=0.15
X1 Y B VGND VNB sky130_fd_pr__nfet_01v8 ad=0.08775 pd=0.92 as=0.08775 ps=0.92 w=0.65 l=0.15
X2 VPWR A a_245_297# VPB sky130_fd_pr__pfet_01v8_hvt ad=0.14575 pd=1.335 as=0.135 ps=1.27 w=1 l=0.15
X3 a_91_199# C_N VGND VNB sky130_fd_pr__nfet_01v8 ad=0.1092 pd=1.36 as=0.10025 ps=0.985 w=0.42 l=0.15
X4 VGND A Y VNB sky130_fd_pr__nfet_01v8 ad=0.10025 pd=0.985 as=0.08775 ps=0.92 w=0.65 l=0.15
X5 a_245_297# B a_161_297# VPB sky130_fd_pr__pfet_01v8_hvt ad=0.135 pd=1.27 as=0.135 ps=1.27 w=1 l=0.15
X6 a_91_199# C_N VPWR VPB sky130_fd_pr__pfet_01v8_hvt ad=0.1092 pd=1.36 as=0.14575 ps=1.335 w=0.42 l=0.15
X7 a_161_297# a_91_199# Y VPB sky130_fd_pr__pfet_01v8_hvt ad=0.135 pd=1.27 as=0.32 ps=2.64 w=1 l=0.15
.ends

.subckt sky130_fd_sc_hd__a21oi_1 VPWR VGND VPB VNB A2 A1 B1 Y
X0 a_199_47# A1 Y VNB sky130_fd_pr__nfet_01v8 ad=0.09588 pd=0.945 as=0.091 ps=0.93 w=0.65 l=0.15
X1 a_113_297# A2 VPWR VPB sky130_fd_pr__pfet_01v8_hvt ad=0.265 pd=2.53 as=0.1475 ps=1.295 w=1 l=0.15
X2 Y B1 VGND VNB sky130_fd_pr__nfet_01v8 ad=0.091 pd=0.93 as=0.17225 ps=1.83 w=0.65 l=0.15
X3 VPWR A1 a_113_297# VPB sky130_fd_pr__pfet_01v8_hvt ad=0.1475 pd=1.295 as=0.14 ps=1.28 w=1 l=0.15
X4 a_113_297# B1 Y VPB sky130_fd_pr__pfet_01v8_hvt ad=0.14 pd=1.28 as=0.265 ps=2.53 w=1 l=0.15
X5 VGND A2 a_199_47# VNB sky130_fd_pr__nfet_01v8 ad=0.17225 pd=1.83 as=0.09588 ps=0.945 w=0.65 l=0.15
.ends

.subckt sky130_fd_sc_hd__decap_6 VPWR VGND VPB VNB
X0 VPWR VGND VPWR VPB sky130_fd_pr__pfet_01v8_hvt ad=0.2262 pd=2.26 as=0.4524 ps=4.52 w=0.87 l=1.97
X1 VGND VPWR VGND VNB sky130_fd_pr__nfet_01v8 ad=0.143 pd=1.62 as=0.286 ps=3.24 w=0.55 l=1.97
.ends

.subckt sky130_fd_sc_hd__nor2_1 VPB VNB VGND VPWR A B Y
X0 VPWR A a_109_297# VPB sky130_fd_pr__pfet_01v8_hvt ad=0.26 pd=2.52 as=0.105 ps=1.21 w=1 l=0.15
X1 VGND A Y VNB sky130_fd_pr__nfet_01v8 ad=0.169 pd=1.82 as=0.08775 ps=0.92 w=0.65 l=0.15
X2 a_109_297# B Y VPB sky130_fd_pr__pfet_01v8_hvt ad=0.105 pd=1.21 as=0.26 ps=2.52 w=1 l=0.15
X3 Y B VGND VNB sky130_fd_pr__nfet_01v8 ad=0.08775 pd=0.92 as=0.169 ps=1.82 w=0.65 l=0.15
.ends

.subckt sky130_fd_sc_hd__clkbuf_1 VGND VPWR X A VPB VNB
X0 VPWR a_75_212# X VPB sky130_fd_pr__pfet_01v8_hvt ad=0.11455 pd=1.08 as=0.2054 ps=2.1 w=0.79 l=0.15
X1 a_75_212# A VGND VNB sky130_fd_pr__nfet_01v8 ad=0.1352 pd=1.56 as=0.0754 ps=0.81 w=0.52 l=0.15
X2 a_75_212# A VPWR VPB sky130_fd_pr__pfet_01v8_hvt ad=0.2054 pd=2.1 as=0.11455 ps=1.08 w=0.79 l=0.15
X3 VGND a_75_212# X VNB sky130_fd_pr__nfet_01v8 ad=0.0754 pd=0.81 as=0.1352 ps=1.56 w=0.52 l=0.15
.ends

.subckt sky130_fd_sc_hd__dfstp_1 VPB VNB VPWR VGND Q SET_B D CLK
X0 VGND a_652_21# a_586_47# VNB sky130_fd_pr__nfet_01v8 ad=0.0882 pd=0.84 as=0.06705 ps=0.75 w=0.42 l=0.15
X1 a_956_413# a_476_47# VPWR VPB sky130_fd_pr__pfet_01v8_hvt ad=0.0483 pd=0.65 as=0.0567 ps=0.69 w=0.42 l=0.15
X2 VPWR a_476_47# a_652_21# VPB sky130_fd_pr__pfet_01v8_hvt ad=0.0567 pd=0.69 as=0.0567 ps=0.69 w=0.42 l=0.15
X3 VPWR CLK a_27_47# VPB sky130_fd_pr__pfet_01v8_hvt ad=0.0864 pd=0.91 as=0.1664 ps=1.8 w=0.64 l=0.15
X4 a_586_47# a_193_47# a_476_47# VNB sky130_fd_pr__special_nfet_01v8 ad=0.06705 pd=0.75 as=0.072 ps=0.76 w=0.36 l=0.15
X5 a_1056_47# a_476_47# VGND VNB sky130_fd_pr__nfet_01v8 ad=0.0441 pd=0.63 as=0.1092 ps=1.36 w=0.42 l=0.15
X6 a_476_47# a_27_47# a_381_47# VNB sky130_fd_pr__special_nfet_01v8 ad=0.072 pd=0.76 as=0.0935 ps=0.965 w=0.36 l=0.15
X7 a_381_47# D VPWR VPB sky130_fd_pr__pfet_01v8_hvt ad=0.12495 pd=1.175 as=0.2184 ps=2.2 w=0.84 l=0.15
X8 a_652_21# SET_B VPWR VPB sky130_fd_pr__pfet_01v8_hvt ad=0.0567 pd=0.69 as=0.0798 ps=0.8 w=0.42 l=0.15
X9 a_1224_47# a_27_47# a_1032_413# VNB sky130_fd_pr__nfet_01v8 ad=0.0441 pd=0.63 as=0.0693 ps=0.75 w=0.42 l=0.15
X10 a_562_413# a_27_47# a_476_47# VPB sky130_fd_pr__pfet_01v8_hvt ad=0.0945 pd=0.87 as=0.0567 ps=0.69 w=0.42 l=0.15
X11 VGND a_1032_413# a_1602_47# VNB sky130_fd_pr__nfet_01v8 ad=0.097 pd=0.975 as=0.1092 ps=1.36 w=0.42 l=0.15
X12 VPWR a_1182_261# a_1140_413# VPB sky130_fd_pr__pfet_01v8_hvt ad=0.1092 pd=1.36 as=0.0441 ps=0.63 w=0.42 l=0.15
X13 Q a_1602_47# VPWR VPB sky130_fd_pr__pfet_01v8_hvt ad=0.26 pd=2.52 as=0.149 ps=1.325 w=1 l=0.15
X14 a_1032_413# a_193_47# a_1056_47# VNB sky130_fd_pr__nfet_01v8 ad=0.0693 pd=0.75 as=0.0441 ps=0.63 w=0.42 l=0.15
X15 a_476_47# a_193_47# a_381_47# VPB sky130_fd_pr__pfet_01v8_hvt ad=0.0567 pd=0.69 as=0.12495 ps=1.175 w=0.42 l=0.15
X16 a_1296_47# a_1182_261# a_1224_47# VNB sky130_fd_pr__nfet_01v8 ad=0.0483 pd=0.65 as=0.0441 ps=0.63 w=0.42 l=0.15
X17 a_193_47# a_27_47# VGND VNB sky130_fd_pr__nfet_01v8 ad=0.1092 pd=1.36 as=0.0567 ps=0.69 w=0.42 l=0.15
X18 VPWR a_652_21# a_562_413# VPB sky130_fd_pr__pfet_01v8_hvt ad=0.0798 pd=0.8 as=0.0945 ps=0.87 w=0.42 l=0.15
X19 VPWR SET_B a_1032_413# VPB sky130_fd_pr__pfet_01v8_hvt ad=0.12285 pd=1.17 as=0.1092 ps=1.36 w=0.42 l=0.15
X20 a_1032_413# a_27_47# a_956_413# VPB sky130_fd_pr__pfet_01v8_hvt ad=0.0819 pd=0.81 as=0.0483 ps=0.65 w=0.42 l=0.15
X21 a_1182_261# a_1032_413# VPWR VPB sky130_fd_pr__pfet_01v8_hvt ad=0.2184 pd=2.2 as=0.12285 ps=1.17 w=0.84 l=0.15
X22 Q a_1602_47# VGND VNB sky130_fd_pr__nfet_01v8 ad=0.169 pd=1.82 as=0.097 ps=0.975 w=0.65 l=0.15
X23 a_193_47# a_27_47# VPWR VPB sky130_fd_pr__pfet_01v8_hvt ad=0.1664 pd=1.8 as=0.0864 ps=0.91 w=0.64 l=0.15
X24 a_1140_413# a_193_47# a_1032_413# VPB sky130_fd_pr__pfet_01v8_hvt ad=0.0441 pd=0.63 as=0.0819 ps=0.81 w=0.42 l=0.15
X25 VPWR a_1032_413# a_1602_47# VPB sky130_fd_pr__pfet_01v8_hvt ad=0.149 pd=1.325 as=0.1664 ps=1.8 w=0.64 l=0.15
X26 a_796_47# SET_B VGND VNB sky130_fd_pr__nfet_01v8 ad=0.0441 pd=0.63 as=0.0882 ps=0.84 w=0.42 l=0.15
X27 a_381_47# D VGND VNB sky130_fd_pr__nfet_01v8 ad=0.0935 pd=0.965 as=0.1664 ps=1.8 w=0.64 l=0.15
X28 a_1182_261# a_1032_413# VGND VNB sky130_fd_pr__nfet_01v8 ad=0.1404 pd=1.6 as=0.1137 ps=1.01 w=0.54 l=0.15
X29 a_652_21# a_476_47# a_796_47# VNB sky130_fd_pr__nfet_01v8 ad=0.1092 pd=1.36 as=0.0441 ps=0.63 w=0.42 l=0.15
X30 VGND CLK a_27_47# VNB sky130_fd_pr__nfet_01v8 ad=0.0567 pd=0.69 as=0.1092 ps=1.36 w=0.42 l=0.15
X31 VGND SET_B a_1296_47# VNB sky130_fd_pr__nfet_01v8 ad=0.1137 pd=1.01 as=0.0483 ps=0.65 w=0.42 l=0.15
.ends

.subckt sky130_fd_sc_hd__nor2b_1 VPB VNB VGND VPWR B_N A Y
X0 Y a_74_47# a_265_297# VPB sky130_fd_pr__pfet_01v8_hvt ad=0.26 pd=2.52 as=0.105 ps=1.21 w=1 l=0.15
X1 VPWR B_N a_74_47# VPB sky130_fd_pr__pfet_01v8_hvt ad=0.1573 pd=1.39 as=0.1092 ps=1.36 w=0.42 l=0.15
X2 a_265_297# A VPWR VPB sky130_fd_pr__pfet_01v8_hvt ad=0.105 pd=1.21 as=0.1573 ps=1.39 w=1 l=0.15
X3 Y A VGND VNB sky130_fd_pr__nfet_01v8 ad=0.08775 pd=0.92 as=0.10025 ps=0.985 w=0.65 l=0.15
X4 VGND B_N a_74_47# VNB sky130_fd_pr__nfet_01v8 ad=0.10025 pd=0.985 as=0.1092 ps=1.36 w=0.42 l=0.15
X5 VGND a_74_47# Y VNB sky130_fd_pr__nfet_01v8 ad=0.169 pd=1.82 as=0.08775 ps=0.92 w=0.65 l=0.15
.ends

.subckt sky130_fd_sc_hd__clkbuf_16 VNB VPB VGND VPWR A X
X0 VPWR A a_110_47# VPB sky130_fd_pr__pfet_01v8_hvt ad=0.14 pd=1.28 as=0.14 ps=1.28 w=1 l=0.15
X1 VPWR a_110_47# X VPB sky130_fd_pr__pfet_01v8_hvt ad=0.14 pd=1.28 as=0.14 ps=1.28 w=1 l=0.15
X2 X a_110_47# VPWR VPB sky130_fd_pr__pfet_01v8_hvt ad=0.14 pd=1.28 as=0.14 ps=1.28 w=1 l=0.15
X3 X a_110_47# VPWR VPB sky130_fd_pr__pfet_01v8_hvt ad=0.14 pd=1.28 as=0.14 ps=1.28 w=1 l=0.15
X4 VPWR a_110_47# X VPB sky130_fd_pr__pfet_01v8_hvt ad=0.14 pd=1.28 as=0.14 ps=1.28 w=1 l=0.15
X5 VPWR a_110_47# X VPB sky130_fd_pr__pfet_01v8_hvt ad=0.265 pd=2.53 as=0.14 ps=1.28 w=1 l=0.15
X6 a_110_47# A VPWR VPB sky130_fd_pr__pfet_01v8_hvt ad=0.14 pd=1.28 as=0.265 ps=2.53 w=1 l=0.15
X7 a_110_47# A VGND VNB sky130_fd_pr__nfet_01v8 ad=0.0588 pd=0.7 as=0.0588 ps=0.7 w=0.42 l=0.15
X8 VGND a_110_47# X VNB sky130_fd_pr__nfet_01v8 ad=0.0588 pd=0.7 as=0.0588 ps=0.7 w=0.42 l=0.15
X9 X a_110_47# VGND VNB sky130_fd_pr__nfet_01v8 ad=0.0588 pd=0.7 as=0.0588 ps=0.7 w=0.42 l=0.15
X10 VGND a_110_47# X VNB sky130_fd_pr__nfet_01v8 ad=0.0588 pd=0.7 as=0.0588 ps=0.7 w=0.42 l=0.15
X11 a_110_47# A VPWR VPB sky130_fd_pr__pfet_01v8_hvt ad=0.14 pd=1.28 as=0.14 ps=1.28 w=1 l=0.15
X12 VGND A a_110_47# VNB sky130_fd_pr__nfet_01v8 ad=0.0588 pd=0.7 as=0.0588 ps=0.7 w=0.42 l=0.15
X13 VGND a_110_47# X VNB sky130_fd_pr__nfet_01v8 ad=0.05775 pd=0.695 as=0.0588 ps=0.7 w=0.42 l=0.15
X14 VPWR a_110_47# X VPB sky130_fd_pr__pfet_01v8_hvt ad=0.14 pd=1.28 as=0.14 ps=1.28 w=1 l=0.15
X15 X a_110_47# VPWR VPB sky130_fd_pr__pfet_01v8_hvt ad=0.14 pd=1.28 as=0.14 ps=1.28 w=1 l=0.15
X16 VGND A a_110_47# VNB sky130_fd_pr__nfet_01v8 ad=0.0588 pd=0.7 as=0.0588 ps=0.7 w=0.42 l=0.15
X17 VGND a_110_47# X VNB sky130_fd_pr__nfet_01v8 ad=0.1113 pd=1.37 as=0.0588 ps=0.7 w=0.42 l=0.15
X18 VPWR a_110_47# X VPB sky130_fd_pr__pfet_01v8_hvt ad=0.1375 pd=1.275 as=0.14 ps=1.28 w=1 l=0.15
X19 VGND a_110_47# X VNB sky130_fd_pr__nfet_01v8 ad=0.0588 pd=0.7 as=0.0588 ps=0.7 w=0.42 l=0.15
X20 X a_110_47# VPWR VPB sky130_fd_pr__pfet_01v8_hvt ad=0.14 pd=1.28 as=0.1375 ps=1.275 w=1 l=0.15
X21 a_110_47# A VGND VNB sky130_fd_pr__nfet_01v8 ad=0.0588 pd=0.7 as=0.1113 ps=1.37 w=0.42 l=0.15
X22 VPWR A a_110_47# VPB sky130_fd_pr__pfet_01v8_hvt ad=0.14 pd=1.28 as=0.14 ps=1.28 w=1 l=0.15
X23 VPWR a_110_47# X VPB sky130_fd_pr__pfet_01v8_hvt ad=0.14 pd=1.28 as=0.14 ps=1.28 w=1 l=0.15
X24 VPWR a_110_47# X VPB sky130_fd_pr__pfet_01v8_hvt ad=0.14 pd=1.28 as=0.14 ps=1.28 w=1 l=0.15
X25 VGND a_110_47# X VNB sky130_fd_pr__nfet_01v8 ad=0.0588 pd=0.7 as=0.0588 ps=0.7 w=0.42 l=0.15
X26 X a_110_47# VPWR VPB sky130_fd_pr__pfet_01v8_hvt ad=0.14 pd=1.28 as=0.14 ps=1.28 w=1 l=0.15
X27 VGND a_110_47# X VNB sky130_fd_pr__nfet_01v8 ad=0.0588 pd=0.7 as=0.0588 ps=0.7 w=0.42 l=0.15
X28 VGND a_110_47# X VNB sky130_fd_pr__nfet_01v8 ad=0.0588 pd=0.7 as=0.0588 ps=0.7 w=0.42 l=0.15
X29 X a_110_47# VGND VNB sky130_fd_pr__nfet_01v8 ad=0.0588 pd=0.7 as=0.0588 ps=0.7 w=0.42 l=0.15
X30 X a_110_47# VPWR VPB sky130_fd_pr__pfet_01v8_hvt ad=0.14 pd=1.28 as=0.14 ps=1.28 w=1 l=0.15
X31 X a_110_47# VPWR VPB sky130_fd_pr__pfet_01v8_hvt ad=0.14 pd=1.28 as=0.14 ps=1.28 w=1 l=0.15
X32 X a_110_47# VGND VNB sky130_fd_pr__nfet_01v8 ad=0.0588 pd=0.7 as=0.0588 ps=0.7 w=0.42 l=0.15
X33 VPWR a_110_47# X VPB sky130_fd_pr__pfet_01v8_hvt ad=0.14 pd=1.28 as=0.14 ps=1.28 w=1 l=0.15
X34 X a_110_47# VPWR VPB sky130_fd_pr__pfet_01v8_hvt ad=0.14 pd=1.28 as=0.14 ps=1.28 w=1 l=0.15
X35 X a_110_47# VGND VNB sky130_fd_pr__nfet_01v8 ad=0.0588 pd=0.7 as=0.0588 ps=0.7 w=0.42 l=0.15
X36 X a_110_47# VGND VNB sky130_fd_pr__nfet_01v8 ad=0.0588 pd=0.7 as=0.0588 ps=0.7 w=0.42 l=0.15
X37 X a_110_47# VGND VNB sky130_fd_pr__nfet_01v8 ad=0.0588 pd=0.7 as=0.0588 ps=0.7 w=0.42 l=0.15
X38 X a_110_47# VGND VNB sky130_fd_pr__nfet_01v8 ad=0.0588 pd=0.7 as=0.0588 ps=0.7 w=0.42 l=0.15
X39 X a_110_47# VGND VNB sky130_fd_pr__nfet_01v8 ad=0.0588 pd=0.7 as=0.05775 ps=0.695 w=0.42 l=0.15
.ends

.subckt sky130_fd_sc_hd__clkdlybuf4s50_1 VNB VPB VGND VPWR A X
X0 a_283_47# a_27_47# VPWR VPB sky130_fd_pr__pfet_01v8_hvt ad=0.2173 pd=2.17 as=0.1701 ps=1.36 w=0.82 l=0.5
X1 VPWR A a_27_47# VPB sky130_fd_pr__pfet_01v8_hvt ad=0.1701 pd=1.36 as=0.27 ps=2.54 w=1 l=0.15
X2 VPWR a_283_47# a_390_47# VPB sky130_fd_pr__pfet_01v8_hvt ad=0.15575 pd=1.325 as=0.2173 ps=2.17 w=0.82 l=0.5
X3 VGND a_283_47# a_390_47# VNB sky130_fd_pr__nfet_01v8 ad=0.097 pd=0.975 as=0.17225 ps=1.83 w=0.65 l=0.5
X4 X a_390_47# VPWR VPB sky130_fd_pr__pfet_01v8_hvt ad=0.355 pd=2.71 as=0.15575 ps=1.325 w=1 l=0.15
X5 VGND A a_27_47# VNB sky130_fd_pr__nfet_01v8 ad=0.10435 pd=1.01 as=0.1134 ps=1.38 w=0.42 l=0.15
X6 a_283_47# a_27_47# VGND VNB sky130_fd_pr__nfet_01v8 ad=0.169 pd=1.82 as=0.10435 ps=1.01 w=0.65 l=0.5
X7 X a_390_47# VGND VNB sky130_fd_pr__nfet_01v8 ad=0.1491 pd=1.55 as=0.097 ps=0.975 w=0.42 l=0.15
.ends

.subckt sky130_fd_sc_hd__a21o_1 VPWR VGND VPB VNB A2 A1 B1 X
X0 a_81_21# B1 VGND VNB sky130_fd_pr__nfet_01v8 ad=0.08937 pd=0.925 as=0.25675 ps=1.44 w=0.65 l=0.15
X1 a_299_297# B1 a_81_21# VPB sky130_fd_pr__pfet_01v8_hvt ad=0.1375 pd=1.275 as=0.26 ps=2.52 w=1 l=0.15
X2 VPWR a_81_21# X VPB sky130_fd_pr__pfet_01v8_hvt ad=0.26 pd=2.52 as=0.26 ps=2.52 w=1 l=0.15
X3 VPWR A1 a_299_297# VPB sky130_fd_pr__pfet_01v8_hvt ad=0.14 pd=1.28 as=0.1375 ps=1.275 w=1 l=0.15
X4 VGND a_81_21# X VNB sky130_fd_pr__nfet_01v8 ad=0.25675 pd=1.44 as=0.169 ps=1.82 w=0.65 l=0.15
X5 VGND A2 a_384_47# VNB sky130_fd_pr__nfet_01v8 ad=0.17225 pd=1.83 as=0.091 ps=0.93 w=0.65 l=0.15
X6 a_299_297# A2 VPWR VPB sky130_fd_pr__pfet_01v8_hvt ad=0.265 pd=2.53 as=0.14 ps=1.28 w=1 l=0.15
X7 a_384_47# A1 a_81_21# VNB sky130_fd_pr__nfet_01v8 ad=0.091 pd=0.93 as=0.08937 ps=0.925 w=0.65 l=0.15
.ends

.subckt sky130_fd_sc_hd__a22o_1 VPWR VGND VPB VNB B1 A1 A2 X B2
X0 VPWR A2 a_109_297# VPB sky130_fd_pr__pfet_01v8_hvt ad=0.155 pd=1.31 as=0.16 ps=1.32 w=1 l=0.15
X1 a_27_297# B1 a_109_47# VNB sky130_fd_pr__nfet_01v8 ad=0.169 pd=1.82 as=0.07475 ps=0.88 w=0.65 l=0.15
X2 VGND A2 a_373_47# VNB sky130_fd_pr__nfet_01v8 ad=0.10075 pd=0.96 as=0.11375 ps=1 w=0.65 l=0.15
X3 X a_27_297# VPWR VPB sky130_fd_pr__pfet_01v8_hvt ad=0.26 pd=2.52 as=0.155 ps=1.31 w=1 l=0.15
X4 a_27_297# B1 a_109_297# VPB sky130_fd_pr__pfet_01v8_hvt ad=0.25285 pd=2.52 as=0.135 ps=1.27 w=1 l=0.15
X5 a_109_297# A1 VPWR VPB sky130_fd_pr__pfet_01v8_hvt ad=0.16 pd=1.32 as=0.2529 ps=2.52 w=1 l=0.15
X6 a_373_47# A1 a_27_297# VNB sky130_fd_pr__nfet_01v8 ad=0.11375 pd=1 as=0.169 ps=1.82 w=0.65 l=0.15
X7 X a_27_297# VGND VNB sky130_fd_pr__nfet_01v8 ad=0.169 pd=1.82 as=0.10075 ps=0.96 w=0.65 l=0.15
X8 a_109_297# B2 a_27_297# VPB sky130_fd_pr__pfet_01v8_hvt ad=0.135 pd=1.27 as=0.26 ps=2.52 w=1 l=0.15
X9 a_109_47# B2 VGND VNB sky130_fd_pr__nfet_01v8 ad=0.07475 pd=0.88 as=0.169 ps=1.82 w=0.65 l=0.15
.ends

.subckt sky130_fd_sc_hd__inv_1 VPB VNB VGND VPWR A Y
X0 Y A VGND VNB sky130_fd_pr__nfet_01v8 ad=0.169 pd=1.82 as=0.169 ps=1.82 w=0.65 l=0.15
X1 Y A VPWR VPB sky130_fd_pr__pfet_01v8_hvt ad=0.26 pd=2.52 as=0.26 ps=2.52 w=1 l=0.15
.ends

.subckt sky130_fd_sc_hd__o21ai_0 VNB VPB VGND VPWR B1 A1 Y A2
X0 a_120_369# A1 VPWR VPB sky130_fd_pr__pfet_01v8_hvt ad=0.0768 pd=0.88 as=0.1696 ps=1.81 w=0.64 l=0.15
X1 VGND A1 a_32_47# VNB sky130_fd_pr__nfet_01v8 ad=0.0588 pd=0.7 as=0.1113 ps=1.37 w=0.42 l=0.15
X2 Y A2 a_120_369# VPB sky130_fd_pr__pfet_01v8_hvt ad=0.0896 pd=0.92 as=0.0768 ps=0.88 w=0.64 l=0.15
X3 a_32_47# A2 VGND VNB sky130_fd_pr__nfet_01v8 ad=0.0588 pd=0.7 as=0.0588 ps=0.7 w=0.42 l=0.15
X4 VPWR B1 Y VPB sky130_fd_pr__pfet_01v8_hvt ad=0.1824 pd=1.85 as=0.0896 ps=0.92 w=0.64 l=0.15
X5 Y B1 a_32_47# VNB sky130_fd_pr__nfet_01v8 ad=0.1113 pd=1.37 as=0.0588 ps=0.7 w=0.42 l=0.15
.ends

.subckt sky130_fd_sc_hd__a31oi_1 VGND VPWR VPB VNB A3 A2 A1 Y B1
X0 Y A1 a_181_47# VNB sky130_fd_pr__nfet_01v8 ad=0.10563 pd=0.975 as=0.11863 ps=1.015 w=0.65 l=0.15
X1 a_181_47# A2 a_109_47# VNB sky130_fd_pr__nfet_01v8 ad=0.11863 pd=1.015 as=0.06825 ps=0.86 w=0.65 l=0.15
X2 VGND B1 Y VNB sky130_fd_pr__nfet_01v8 ad=0.1755 pd=1.84 as=0.10563 ps=0.975 w=0.65 l=0.15
X3 VPWR A2 a_109_297# VPB sky130_fd_pr__pfet_01v8_hvt ad=0.1525 pd=1.305 as=0.135 ps=1.27 w=1 l=0.15
X4 Y B1 a_109_297# VPB sky130_fd_pr__pfet_01v8_hvt ad=0.27 pd=2.54 as=0.1625 ps=1.325 w=1 l=0.15
X5 a_109_297# A1 VPWR VPB sky130_fd_pr__pfet_01v8_hvt ad=0.1625 pd=1.325 as=0.1525 ps=1.305 w=1 l=0.15
X6 a_109_297# A3 VPWR VPB sky130_fd_pr__pfet_01v8_hvt ad=0.135 pd=1.27 as=0.26 ps=2.52 w=1 l=0.15
X7 a_109_47# A3 VGND VNB sky130_fd_pr__nfet_01v8 ad=0.06825 pd=0.86 as=0.169 ps=1.82 w=0.65 l=0.15
.ends

.subckt sky130_fd_sc_hd__nand3b_1 VPB VNB VGND VPWR Y B C A_N
X0 Y a_53_93# VPWR VPB sky130_fd_pr__pfet_01v8_hvt ad=0.28 pd=2.56 as=0.1925 ps=1.385 w=1 l=0.15
X1 a_232_47# C VGND VNB sky130_fd_pr__nfet_01v8 ad=0.08775 pd=0.92 as=0.10025 ps=0.985 w=0.65 l=0.15
X2 VPWR B Y VPB sky130_fd_pr__pfet_01v8_hvt ad=0.1925 pd=1.385 as=0.135 ps=1.27 w=1 l=0.15
X3 VPWR A_N a_53_93# VPB sky130_fd_pr__pfet_01v8_hvt ad=0.14575 pd=1.335 as=0.1092 ps=1.36 w=0.42 l=0.15
X4 VGND A_N a_53_93# VNB sky130_fd_pr__nfet_01v8 ad=0.10025 pd=0.985 as=0.1092 ps=1.36 w=0.42 l=0.15
X5 a_316_47# B a_232_47# VNB sky130_fd_pr__nfet_01v8 ad=0.12513 pd=1.035 as=0.08775 ps=0.92 w=0.65 l=0.15
X6 Y a_53_93# a_316_47# VNB sky130_fd_pr__nfet_01v8 ad=0.182 pd=1.86 as=0.12513 ps=1.035 w=0.65 l=0.15
X7 Y C VPWR VPB sky130_fd_pr__pfet_01v8_hvt ad=0.135 pd=1.27 as=0.14575 ps=1.335 w=1 l=0.15
.ends

.subckt sky130_fd_sc_hd__nor3_1 VPB VNB VGND VPWR C B A Y
X0 VPWR A a_193_297# VPB sky130_fd_pr__pfet_01v8_hvt ad=0.26 pd=2.52 as=0.135 ps=1.27 w=1 l=0.15
X1 a_193_297# B a_109_297# VPB sky130_fd_pr__pfet_01v8_hvt ad=0.135 pd=1.27 as=0.135 ps=1.27 w=1 l=0.15
X2 Y B VGND VNB sky130_fd_pr__nfet_01v8 ad=0.08775 pd=0.92 as=0.08775 ps=0.92 w=0.65 l=0.15
X3 VGND A Y VNB sky130_fd_pr__nfet_01v8 ad=0.169 pd=1.82 as=0.08775 ps=0.92 w=0.65 l=0.15
X4 a_109_297# C Y VPB sky130_fd_pr__pfet_01v8_hvt ad=0.135 pd=1.27 as=0.26 ps=2.52 w=1 l=0.15
X5 VGND C Y VNB sky130_fd_pr__nfet_01v8 ad=0.08775 pd=0.92 as=0.169 ps=1.82 w=0.65 l=0.15
.ends

.subckt sky130_fd_sc_hd__or2_0 VNB VPB VGND VPWR B A X
X0 VGND A a_68_355# VNB sky130_fd_pr__nfet_01v8 ad=0.07035 pd=0.755 as=0.0567 ps=0.69 w=0.42 l=0.15
X1 a_150_355# B a_68_355# VPB sky130_fd_pr__pfet_01v8_hvt ad=0.0441 pd=0.63 as=0.1092 ps=1.36 w=0.42 l=0.15
X2 a_68_355# B VGND VNB sky130_fd_pr__nfet_01v8 ad=0.0567 pd=0.69 as=0.1092 ps=1.36 w=0.42 l=0.15
X3 X a_68_355# VGND VNB sky130_fd_pr__nfet_01v8 ad=0.1092 pd=1.36 as=0.07035 ps=0.755 w=0.42 l=0.15
X4 VPWR A a_150_355# VPB sky130_fd_pr__pfet_01v8_hvt ad=0.09895 pd=0.975 as=0.0441 ps=0.63 w=0.42 l=0.15
X5 X a_68_355# VPWR VPB sky130_fd_pr__pfet_01v8_hvt ad=0.2176 pd=1.96 as=0.09895 ps=0.975 w=0.64 l=0.15
.ends

.subckt sky130_fd_sc_hd__o31a_1 X A1 A2 A3 B1 VPB VNB VGND VPWR
X0 a_103_199# B1 a_253_47# VNB sky130_fd_pr__nfet_01v8 ad=0.2015 pd=1.92 as=0.10725 ps=0.98 w=0.65 l=0.15
X1 VPWR a_103_199# X VPB sky130_fd_pr__pfet_01v8_hvt ad=0.195 pd=1.39 as=0.36 ps=2.72 w=1 l=0.15
X2 a_337_297# A2 a_253_297# VPB sky130_fd_pr__pfet_01v8_hvt ad=0.165 pd=1.33 as=0.135 ps=1.27 w=1 l=0.15
X3 a_103_199# A3 a_337_297# VPB sky130_fd_pr__pfet_01v8_hvt ad=0.2125 pd=1.425 as=0.165 ps=1.33 w=1 l=0.15
X4 a_253_297# A1 VPWR VPB sky130_fd_pr__pfet_01v8_hvt ad=0.135 pd=1.27 as=0.195 ps=1.39 w=1 l=0.15
X5 VPWR B1 a_103_199# VPB sky130_fd_pr__pfet_01v8_hvt ad=0.345 pd=2.69 as=0.2125 ps=1.425 w=1 l=0.15
X6 VGND a_103_199# X VNB sky130_fd_pr__nfet_01v8 ad=0.12675 pd=1.04 as=0.234 ps=2.02 w=0.65 l=0.15
X7 a_253_47# A1 VGND VNB sky130_fd_pr__nfet_01v8 ad=0.08775 pd=0.92 as=0.12675 ps=1.04 w=0.65 l=0.15
X8 a_253_47# A3 VGND VNB sky130_fd_pr__nfet_01v8 ad=0.10725 pd=0.98 as=0.10725 ps=0.98 w=0.65 l=0.15
X9 VGND A2 a_253_47# VNB sky130_fd_pr__nfet_01v8 ad=0.10725 pd=0.98 as=0.08775 ps=0.92 w=0.65 l=0.15
.ends

.subckt sky130_fd_sc_hd__and3_1 VGND VPWR X B A C VPB VNB
X0 VPWR A a_27_47# VPB sky130_fd_pr__pfet_01v8_hvt ad=0.0567 pd=0.69 as=0.1092 ps=1.36 w=0.42 l=0.15
X1 VPWR C a_27_47# VPB sky130_fd_pr__pfet_01v8_hvt ad=0.14222 pd=1.335 as=0.06615 ps=0.735 w=0.42 l=0.15
X2 a_181_47# B a_109_47# VNB sky130_fd_pr__nfet_01v8 ad=0.0441 pd=0.63 as=0.0441 ps=0.63 w=0.42 l=0.15
X3 VGND C a_181_47# VNB sky130_fd_pr__nfet_01v8 ad=0.13165 pd=1.14 as=0.0441 ps=0.63 w=0.42 l=0.15
X4 a_27_47# B VPWR VPB sky130_fd_pr__pfet_01v8_hvt ad=0.06615 pd=0.735 as=0.0567 ps=0.69 w=0.42 l=0.15
X5 X a_27_47# VPWR VPB sky130_fd_pr__pfet_01v8_hvt ad=0.26 pd=2.52 as=0.14222 ps=1.335 w=1 l=0.15
X6 X a_27_47# VGND VNB sky130_fd_pr__nfet_01v8 ad=0.169 pd=1.82 as=0.13165 ps=1.14 w=0.65 l=0.15
X7 a_109_47# A a_27_47# VNB sky130_fd_pr__nfet_01v8 ad=0.0441 pd=0.63 as=0.1092 ps=1.36 w=0.42 l=0.15
.ends

.subckt sky130_fd_sc_hd__or3b_1 VGND VPWR VPB VNB B C_N A X
X0 a_109_93# C_N VGND VNB sky130_fd_pr__nfet_01v8 ad=0.1092 pd=1.36 as=0.1092 ps=1.36 w=0.42 l=0.15
X1 a_215_53# B VGND VNB sky130_fd_pr__nfet_01v8 ad=0.0567 pd=0.69 as=0.0567 ps=0.69 w=0.42 l=0.15
X2 VGND a_109_93# a_215_53# VNB sky130_fd_pr__nfet_01v8 ad=0.0567 pd=0.69 as=0.1092 ps=1.36 w=0.42 l=0.15
X3 VGND A a_215_53# VNB sky130_fd_pr__nfet_01v8 ad=0.10025 pd=0.985 as=0.0567 ps=0.69 w=0.42 l=0.15
X4 VPWR A a_369_297# VPB sky130_fd_pr__pfet_01v8_hvt ad=0.14825 pd=1.34 as=0.06825 ps=0.745 w=0.42 l=0.15
X5 a_369_297# B a_297_297# VPB sky130_fd_pr__pfet_01v8_hvt ad=0.06825 pd=0.745 as=0.0441 ps=0.63 w=0.42 l=0.15
X6 X a_215_53# VPWR VPB sky130_fd_pr__pfet_01v8_hvt ad=0.275 pd=2.55 as=0.14825 ps=1.34 w=1 l=0.15
X7 a_297_297# a_109_93# a_215_53# VPB sky130_fd_pr__pfet_01v8_hvt ad=0.0441 pd=0.63 as=0.1092 ps=1.36 w=0.42 l=0.15
X8 a_109_93# C_N VPWR VPB sky130_fd_pr__pfet_01v8_hvt ad=0.1092 pd=1.36 as=0.1092 ps=1.36 w=0.42 l=0.15
X9 X a_215_53# VGND VNB sky130_fd_pr__nfet_01v8 ad=0.17875 pd=1.85 as=0.10025 ps=0.985 w=0.65 l=0.15
.ends

.subckt sky130_fd_sc_hd__a22oi_1 VPWR VGND VPB VNB B2 B1 Y A1 A2
X0 Y B1 a_109_47# VNB sky130_fd_pr__nfet_01v8 ad=0.169 pd=1.82 as=0.07475 ps=0.88 w=0.65 l=0.15
X1 Y B1 a_109_297# VPB sky130_fd_pr__pfet_01v8_hvt ad=0.26 pd=2.52 as=0.135 ps=1.27 w=1 l=0.15
X2 VPWR A2 a_109_297# VPB sky130_fd_pr__pfet_01v8_hvt ad=0.3 pd=2.6 as=0.135 ps=1.27 w=1 l=0.15
X3 a_109_297# A1 VPWR VPB sky130_fd_pr__pfet_01v8_hvt ad=0.135 pd=1.27 as=0.26 ps=2.52 w=1 l=0.15
X4 a_381_47# A1 Y VNB sky130_fd_pr__nfet_01v8 ad=0.06825 pd=0.86 as=0.169 ps=1.82 w=0.65 l=0.15
X5 a_109_297# B2 Y VPB sky130_fd_pr__pfet_01v8_hvt ad=0.135 pd=1.27 as=0.26 ps=2.52 w=1 l=0.15
X6 a_109_47# B2 VGND VNB sky130_fd_pr__nfet_01v8 ad=0.07475 pd=0.88 as=0.169 ps=1.82 w=0.65 l=0.15
X7 VGND A2 a_381_47# VNB sky130_fd_pr__nfet_01v8 ad=0.234 pd=2.02 as=0.06825 ps=0.86 w=0.65 l=0.15
.ends

.subckt sky130_fd_sc_hd__buf_1 VGND VPWR X A VPB VNB
X0 VPWR A a_27_47# VPB sky130_fd_pr__pfet_01v8_hvt ad=0.11455 pd=1.08 as=0.2054 ps=2.1 w=0.79 l=0.15
X1 X a_27_47# VGND VNB sky130_fd_pr__nfet_01v8 ad=0.1352 pd=1.56 as=0.0754 ps=0.81 w=0.52 l=0.15
X2 X a_27_47# VPWR VPB sky130_fd_pr__pfet_01v8_hvt ad=0.2054 pd=2.1 as=0.11455 ps=1.08 w=0.79 l=0.15
X3 VGND A a_27_47# VNB sky130_fd_pr__nfet_01v8 ad=0.0754 pd=0.81 as=0.1352 ps=1.56 w=0.52 l=0.15
.ends

.subckt sky130_fd_sc_hd__nand4b_1 VPB VNB VGND VPWR Y C B D A_N
X0 Y B VPWR VPB sky130_fd_pr__pfet_01v8_hvt ad=0.195 pd=1.39 as=0.1925 ps=1.385 w=1 l=0.15
X1 a_232_47# D VGND VNB sky130_fd_pr__nfet_01v8 ad=0.08775 pd=0.92 as=0.11812 ps=1.04 w=0.65 l=0.15
X2 VPWR C Y VPB sky130_fd_pr__pfet_01v8_hvt ad=0.1925 pd=1.385 as=0.135 ps=1.27 w=1 l=0.15
X3 VPWR A_N a_41_93# VPB sky130_fd_pr__pfet_01v8_hvt ad=0.14575 pd=1.335 as=0.1092 ps=1.36 w=0.42 l=0.15
X4 VPWR a_41_93# Y VPB sky130_fd_pr__pfet_01v8_hvt ad=0.28 pd=2.56 as=0.195 ps=1.39 w=1 l=0.15
X5 a_316_47# C a_232_47# VNB sky130_fd_pr__nfet_01v8 ad=0.12513 pd=1.035 as=0.08775 ps=0.92 w=0.65 l=0.15
X6 Y a_41_93# a_423_47# VNB sky130_fd_pr__nfet_01v8 ad=0.2275 pd=2 as=0.12675 ps=1.04 w=0.65 l=0.15
X7 a_423_47# B a_316_47# VNB sky130_fd_pr__nfet_01v8 ad=0.12675 pd=1.04 as=0.12513 ps=1.035 w=0.65 l=0.15
X8 Y D VPWR VPB sky130_fd_pr__pfet_01v8_hvt ad=0.135 pd=1.27 as=0.14575 ps=1.335 w=1 l=0.15
X9 VGND A_N a_41_93# VNB sky130_fd_pr__nfet_01v8 ad=0.11812 pd=1.04 as=0.1113 ps=1.37 w=0.42 l=0.15
.ends

.subckt sky130_fd_sc_hd__mux2i_1 VPB VNB VGND VPWR A0 Y A1 S
X0 a_27_297# S VPWR VPB sky130_fd_pr__pfet_01v8_hvt ad=0.26 pd=2.52 as=0.3 ps=1.6 w=1 l=0.15
X1 VGND S a_283_205# VNB sky130_fd_pr__nfet_01v8 ad=0.169 pd=1.82 as=0.169 ps=1.82 w=0.65 l=0.15
X2 a_204_297# A1 Y VPB sky130_fd_pr__pfet_01v8_hvt ad=0.1975 pd=1.395 as=0.1525 ps=1.305 w=1 l=0.15
X3 a_193_47# A1 Y VNB sky130_fd_pr__nfet_01v8 ad=0.182 pd=1.86 as=0.08775 ps=0.92 w=0.65 l=0.15
X4 Y A0 a_27_297# VPB sky130_fd_pr__pfet_01v8_hvt ad=0.1525 pd=1.305 as=0.28 ps=2.56 w=1 l=0.15
X5 VPWR a_283_205# a_204_297# VPB sky130_fd_pr__pfet_01v8_hvt ad=0.3 pd=1.6 as=0.1975 ps=1.395 w=1 l=0.15
X6 VPWR S a_283_205# VPB sky130_fd_pr__pfet_01v8_hvt ad=0.26 pd=2.52 as=0.29 ps=2.58 w=1 l=0.15
X7 VGND a_283_205# a_27_47# VNB sky130_fd_pr__nfet_01v8 ad=0.08775 pd=0.92 as=0.169 ps=1.82 w=0.65 l=0.15
X8 a_193_47# S VGND VNB sky130_fd_pr__nfet_01v8 ad=0.169 pd=1.82 as=0.08775 ps=0.92 w=0.65 l=0.15
X9 Y A0 a_27_47# VNB sky130_fd_pr__nfet_01v8 ad=0.08775 pd=0.92 as=0.169 ps=1.82 w=0.65 l=0.15
.ends

.subckt sky130_fd_sc_hd__a221o_1 VPWR VGND VPB VNB A1 A2 X B1 B2 C1
X0 a_465_47# A1 a_27_47# VNB sky130_fd_pr__nfet_01v8 ad=0.10725 pd=0.98 as=0.169 ps=1.82 w=0.65 l=0.15
X1 X a_27_47# VPWR VPB sky130_fd_pr__pfet_01v8_hvt ad=0.26 pd=2.52 as=0.1575 ps=1.315 w=1 l=0.15
X2 a_109_297# B1 a_193_297# VPB sky130_fd_pr__pfet_01v8_hvt ad=0.26 pd=2.52 as=0.135 ps=1.27 w=1 l=0.15
X3 a_193_297# B2 a_109_297# VPB sky130_fd_pr__pfet_01v8_hvt ad=0.135 pd=1.27 as=0.135 ps=1.27 w=1 l=0.15
X4 X a_27_47# VGND VNB sky130_fd_pr__nfet_01v8 ad=0.169 pd=1.82 as=0.10238 ps=0.965 w=0.65 l=0.15
X5 a_205_47# B2 VGND VNB sky130_fd_pr__nfet_01v8 ad=0.06825 pd=0.86 as=0.10725 ps=0.98 w=0.65 l=0.15
X6 VPWR A2 a_193_297# VPB sky130_fd_pr__pfet_01v8_hvt ad=0.1575 pd=1.315 as=0.165 ps=1.33 w=1 l=0.15
X7 a_193_297# A1 VPWR VPB sky130_fd_pr__pfet_01v8_hvt ad=0.165 pd=1.33 as=0.26 ps=2.52 w=1 l=0.15
X8 a_27_47# B1 a_205_47# VNB sky130_fd_pr__nfet_01v8 ad=0.169 pd=1.82 as=0.06825 ps=0.86 w=0.65 l=0.15
X9 a_109_297# C1 a_27_47# VPB sky130_fd_pr__pfet_01v8_hvt ad=0.135 pd=1.27 as=0.26 ps=2.52 w=1 l=0.15
X10 VGND C1 a_27_47# VNB sky130_fd_pr__nfet_01v8 ad=0.10725 pd=0.98 as=0.169 ps=1.82 w=0.65 l=0.15
X11 VGND A2 a_465_47# VNB sky130_fd_pr__nfet_01v8 ad=0.10238 pd=0.965 as=0.10725 ps=0.98 w=0.65 l=0.15
.ends

.subckt sky130_fd_sc_hd__a41oi_1 VGND VPWR A4 Y B1 A1 A2 A3 VPB VNB
X0 a_236_47# A4 VGND VNB sky130_fd_pr__nfet_01v8 ad=0.11375 pd=1 as=0.16342 ps=1.175 w=0.65 l=0.15
X1 a_428_47# A2 a_336_47# VNB sky130_fd_pr__nfet_01v8 ad=0.13813 pd=1.075 as=0.10075 ps=0.96 w=0.65 l=0.15
X2 a_109_297# A1 VPWR VPB sky130_fd_pr__pfet_01v8_hvt ad=0.37 pd=2.74 as=0.2125 ps=1.425 w=1 l=0.15
X3 Y A1 a_428_47# VNB sky130_fd_pr__nfet_01v8 ad=0.2405 pd=2.04 as=0.13813 ps=1.075 w=0.65 l=0.15
X4 a_336_47# A3 a_236_47# VNB sky130_fd_pr__nfet_01v8 ad=0.10075 pd=0.96 as=0.11375 ps=1 w=0.65 l=0.15
X5 VPWR A4 a_109_297# VPB sky130_fd_pr__pfet_01v8_hvt ad=0.205 pd=1.41 as=0.2125 ps=1.425 w=1 l=0.15
X6 a_109_297# B1 Y VPB sky130_fd_pr__pfet_01v8_hvt ad=0.2125 pd=1.425 as=0.26 ps=2.52 w=1 l=0.15
X7 a_109_297# A3 VPWR VPB sky130_fd_pr__pfet_01v8_hvt ad=0.155 pd=1.31 as=0.205 ps=1.41 w=1 l=0.15
X8 VPWR A2 a_109_297# VPB sky130_fd_pr__pfet_01v8_hvt ad=0.2125 pd=1.425 as=0.155 ps=1.31 w=1 l=0.15
X9 VGND B1 Y VNB sky130_fd_pr__nfet_01v8 ad=0.16342 pd=1.175 as=0.169 ps=1.82 w=0.65 l=0.15
.ends

.subckt sky130_fd_sc_hd__o2111ai_1 VPB VNB VGND VPWR Y A1 A2 C1 D1 B1
X0 VPWR C1 Y VPB sky130_fd_pr__pfet_01v8_hvt ad=0.195 pd=1.39 as=0.14 ps=1.28 w=1 l=0.15
X1 a_235_47# C1 a_163_47# VNB sky130_fd_pr__nfet_01v8 ad=0.12675 pd=1.04 as=0.06825 ps=0.86 w=0.65 l=0.15
X2 a_343_47# B1 a_235_47# VNB sky130_fd_pr__nfet_01v8 ad=0.13162 pd=1.055 as=0.12675 ps=1.04 w=0.65 l=0.15
X3 Y B1 VPWR VPB sky130_fd_pr__pfet_01v8_hvt ad=0.2025 pd=1.405 as=0.195 ps=1.39 w=1 l=0.15
X4 a_454_297# A2 Y VPB sky130_fd_pr__pfet_01v8_hvt ad=0.195 pd=1.39 as=0.2025 ps=1.405 w=1 l=0.15
X5 Y D1 VPWR VPB sky130_fd_pr__pfet_01v8_hvt ad=0.14 pd=1.28 as=0.265 ps=2.53 w=1 l=0.15
X6 VPWR A1 a_454_297# VPB sky130_fd_pr__pfet_01v8_hvt ad=0.265 pd=2.53 as=0.195 ps=1.39 w=1 l=0.15
X7 a_163_47# D1 Y VNB sky130_fd_pr__nfet_01v8 ad=0.06825 pd=0.86 as=0.17225 ps=1.83 w=0.65 l=0.15
X8 VGND A2 a_343_47# VNB sky130_fd_pr__nfet_01v8 ad=0.12675 pd=1.04 as=0.13162 ps=1.055 w=0.65 l=0.15
X9 a_343_47# A1 VGND VNB sky130_fd_pr__nfet_01v8 ad=0.17225 pd=1.83 as=0.12675 ps=1.04 w=0.65 l=0.15
.ends

.subckt sky130_fd_sc_hd__a2bb2oi_1 VPB VNB VGND VPWR Y A2_N A1_N B2 B1
X0 a_109_47# A2_N a_109_297# VPB sky130_fd_pr__pfet_01v8_hvt ad=0.26 pd=2.52 as=0.105 ps=1.21 w=1 l=0.15
X1 a_397_297# B1 VPWR VPB sky130_fd_pr__pfet_01v8_hvt ad=0.26 pd=2.52 as=0.135 ps=1.27 w=1 l=0.15
X2 VPWR B2 a_397_297# VPB sky130_fd_pr__pfet_01v8_hvt ad=0.135 pd=1.27 as=0.135 ps=1.27 w=1 l=0.15
X3 VGND A2_N a_109_47# VNB sky130_fd_pr__nfet_01v8 ad=0.28275 pd=1.52 as=0.08775 ps=0.92 w=0.65 l=0.15
X4 a_397_297# a_109_47# Y VPB sky130_fd_pr__pfet_01v8_hvt ad=0.135 pd=1.27 as=0.34 ps=2.68 w=1 l=0.15
X5 a_481_47# B2 Y VNB sky130_fd_pr__nfet_01v8 ad=0.08775 pd=0.92 as=0.08775 ps=0.92 w=0.65 l=0.15
X6 Y a_109_47# VGND VNB sky130_fd_pr__nfet_01v8 ad=0.08775 pd=0.92 as=0.28275 ps=1.52 w=0.65 l=0.15
X7 VGND B1 a_481_47# VNB sky130_fd_pr__nfet_01v8 ad=0.169 pd=1.82 as=0.08775 ps=0.92 w=0.65 l=0.15
X8 a_109_297# A1_N VPWR VPB sky130_fd_pr__pfet_01v8_hvt ad=0.105 pd=1.21 as=0.26 ps=2.52 w=1 l=0.15
X9 a_109_47# A1_N VGND VNB sky130_fd_pr__nfet_01v8 ad=0.08775 pd=0.92 as=0.169 ps=1.82 w=0.65 l=0.15
.ends

.subckt sky130_fd_sc_hd__conb_1 LO HI VPB VNB VGND VPWR
X0 VPWR HI sky130_fd_pr__res_generic_po w=0.48 l=0.5
X1 LO VGND sky130_fd_pr__res_generic_po w=0.48 l=0.5
.ends

.subckt sky130_fd_sc_hd__o221ai_1 VPB VNB VGND VPWR A1 A2 Y B2 C1 B1
X0 a_109_47# B1 a_213_123# VNB sky130_fd_pr__nfet_01v8 ad=0.08775 pd=0.92 as=0.1652 ps=1.82 w=0.65 l=0.15
X1 Y B2 a_295_297# VPB sky130_fd_pr__pfet_01v8_hvt ad=0.225 pd=1.45 as=0.12 ps=1.24 w=1 l=0.15
X2 VPWR A1 a_493_297# VPB sky130_fd_pr__pfet_01v8_hvt ad=0.26 pd=2.52 as=0.105 ps=1.21 w=1 l=0.15
X3 a_213_123# B2 a_109_47# VNB sky130_fd_pr__nfet_01v8 ad=0.117 pd=1.01 as=0.08775 ps=0.92 w=0.65 l=0.15
X4 a_295_297# B1 VPWR VPB sky130_fd_pr__pfet_01v8_hvt ad=0.12 pd=1.24 as=0.38 ps=1.76 w=1 l=0.15
X5 a_493_297# A2 Y VPB sky130_fd_pr__pfet_01v8_hvt ad=0.105 pd=1.21 as=0.225 ps=1.45 w=1 l=0.15
X6 VPWR C1 Y VPB sky130_fd_pr__pfet_01v8_hvt ad=0.38 pd=1.76 as=0.28 ps=2.56 w=1 l=0.15
X7 VGND A2 a_213_123# VNB sky130_fd_pr__nfet_01v8 ad=0.08775 pd=0.92 as=0.117 ps=1.01 w=0.65 l=0.15
X8 a_213_123# A1 VGND VNB sky130_fd_pr__nfet_01v8 ad=0.169 pd=1.82 as=0.08775 ps=0.92 w=0.65 l=0.15
X9 a_109_47# C1 Y VNB sky130_fd_pr__nfet_01v8 ad=0.1654 pd=1.82 as=0.169 ps=1.82 w=0.65 l=0.15
.ends

.subckt sky130_fd_sc_hd__o311ai_0 C1 A1 A2 Y B1 A3 VPB VNB VGND VPWR
X0 VGND A2 a_138_47# VNB sky130_fd_pr__nfet_01v8 ad=0.0567 pd=0.69 as=0.0567 ps=0.69 w=0.42 l=0.15
X1 a_138_369# A1 VPWR VPB sky130_fd_pr__pfet_01v8_hvt ad=0.0864 pd=0.91 as=0.1792 ps=1.84 w=0.64 l=0.15
X2 a_138_47# A1 VGND VNB sky130_fd_pr__nfet_01v8 ad=0.0567 pd=0.69 as=0.1176 ps=1.4 w=0.42 l=0.15
X3 a_138_47# A3 VGND VNB sky130_fd_pr__nfet_01v8 ad=0.1281 pd=1.03 as=0.0567 ps=0.69 w=0.42 l=0.15
X4 Y C1 a_458_47# VNB sky130_fd_pr__nfet_01v8 ad=0.1176 pd=1.4 as=0.0441 ps=0.63 w=0.42 l=0.15
X5 Y C1 VPWR VPB sky130_fd_pr__pfet_01v8_hvt ad=0.1984 pd=1.9 as=0.1184 ps=1.01 w=0.64 l=0.15
X6 Y A3 a_222_369# VPB sky130_fd_pr__pfet_01v8_hvt ad=0.144 pd=1.09 as=0.0864 ps=0.91 w=0.64 l=0.15
X7 a_222_369# A2 a_138_369# VPB sky130_fd_pr__pfet_01v8_hvt ad=0.0864 pd=0.91 as=0.0864 ps=0.91 w=0.64 l=0.15
X8 a_458_47# B1 a_138_47# VNB sky130_fd_pr__nfet_01v8 ad=0.0441 pd=0.63 as=0.1281 ps=1.03 w=0.42 l=0.15
X9 VPWR B1 Y VPB sky130_fd_pr__pfet_01v8_hvt ad=0.1184 pd=1.01 as=0.144 ps=1.09 w=0.64 l=0.15
.ends

.subckt sky130_fd_sc_hd__o21a_1 VPB VNB VGND VPWR A1 A2 B1 X
X0 VPWR A1 a_382_297# VPB sky130_fd_pr__pfet_01v8_hvt ad=0.26 pd=2.52 as=0.1525 ps=1.305 w=1 l=0.15
X1 a_297_47# B1 a_79_21# VNB sky130_fd_pr__nfet_01v8 ad=0.10075 pd=0.96 as=0.169 ps=1.82 w=0.65 l=0.15
X2 a_297_47# A1 VGND VNB sky130_fd_pr__nfet_01v8 ad=0.169 pd=1.82 as=0.08775 ps=0.92 w=0.65 l=0.15
X3 VGND A2 a_297_47# VNB sky130_fd_pr__nfet_01v8 ad=0.08775 pd=0.92 as=0.10075 ps=0.96 w=0.65 l=0.15
X4 VPWR a_79_21# X VPB sky130_fd_pr__pfet_01v8_hvt ad=0.3275 pd=1.655 as=0.28 ps=2.56 w=1 l=0.15
X5 a_79_21# B1 VPWR VPB sky130_fd_pr__pfet_01v8_hvt ad=0.195 pd=1.39 as=0.3275 ps=1.655 w=1 l=0.15
X6 a_382_297# A2 a_79_21# VPB sky130_fd_pr__pfet_01v8_hvt ad=0.1525 pd=1.305 as=0.195 ps=1.39 w=1 l=0.15
X7 VGND a_79_21# X VNB sky130_fd_pr__nfet_01v8 ad=0.169 pd=1.82 as=0.169 ps=1.82 w=0.65 l=0.15
.ends

.subckt sar_logic clk cmp cmp_clk dout[0] dout[1] dout[2] dout[3] dout[4] dout[5]
+ dout[6] dout[7] eoc n[0] n[1] n[2] n[3] n[4] n[5] n[6] n[7] nd p[0] p[1] p[2] p[3]
+ p[4] p[5] p[6] p[7] pd rst_n s sb st stb VPWR VGND
XFILLER_3_23 VPWR VGND VPWR VGND sky130_fd_sc_hd__decap_3
XFILLER_13_133 VGND VPWR VPWR VGND sky130_fd_sc_hd__decap_12
X_200_ VGND VPWR VPWR VGND _200_/CLK _200_/D fanout46/X _200_/Q sky130_fd_sc_hd__dfrtp_1
X_131_ VPWR VGND VGND VPWR _135_/A _131_/Y _131_/B sky130_fd_sc_hd__nand2_1
X_114_ VGND VPWR VPWR VGND _180_/D _193_/Q _201_/D hold65/X sky130_fd_sc_hd__mux2_1
Xhold63 _112_/B _179_/Q VPWR VGND VGND VPWR sky130_fd_sc_hd__dlygate4sd3_1
Xhold52 _080_/A _170_/Q VPWR VGND VGND VPWR sky130_fd_sc_hd__dlygate4sd3_1
XPHY_EDGE_ROW_16_Left_37 VPWR VGND VPWR VGND sky130_fd_sc_hd__decap_3
Xoutput7 VPWR VGND dout[3] _176_/Q VPWR VGND sky130_fd_sc_hd__buf_2
Xoutput31 VPWR VGND sb _079_/Y VPWR VGND sky130_fd_sc_hd__buf_2
Xoutput20 VPWR VGND n[7] _109_/Y VPWR VGND sky130_fd_sc_hd__buf_2
XFILLER_16_131 VPWR VGND VPWR VGND sky130_fd_sc_hd__decap_8
XFILLER_3_57 VGND VPWR VPWR VGND sky130_fd_sc_hd__decap_4
XPHY_EDGE_ROW_19_Left_40 VPWR VGND VPWR VGND sky130_fd_sc_hd__decap_3
XPHY_EDGE_ROW_4_Left_25 VPWR VGND VPWR VGND sky130_fd_sc_hd__decap_3
XPHY_EDGE_ROW_12_Right_12 VPWR VGND VPWR VGND sky130_fd_sc_hd__decap_3
X_130_ VPWR VGND VGND VPWR _134_/B _130_/B _131_/B _134_/A sky130_fd_sc_hd__nor3b_1
X_113_ VPWR VGND VPWR VGND _086_/Y _201_/D _112_/Y _113_/Y sky130_fd_sc_hd__a21oi_1
Xhold53 _090_/A _182_/Q VPWR VGND VGND VPWR sky130_fd_sc_hd__dlygate4sd3_1
XFILLER_20_66 VGND VPWR VPWR VGND sky130_fd_sc_hd__decap_4
Xhold64 _179_/D _113_/Y VPWR VGND VGND VPWR sky130_fd_sc_hd__dlygate4sd3_1
XPHY_EDGE_ROW_6_Right_6 VPWR VGND VPWR VGND sky130_fd_sc_hd__decap_3
Xoutput8 VPWR VGND dout[4] _177_/Q VPWR VGND sky130_fd_sc_hd__buf_2
Xoutput10 VPWR VGND dout[6] _179_/Q VPWR VGND sky130_fd_sc_hd__buf_2
Xoutput21 VPWR VGND nd _109_/B_N VPWR VGND sky130_fd_sc_hd__buf_2
Xoutput32 VPWR VGND st _170_/Q VPWR VGND sky130_fd_sc_hd__buf_2
XFILLER_3_69 VPWR VGND VPWR VGND sky130_fd_sc_hd__decap_6
XPHY_EDGE_ROW_20_Left_41 VPWR VGND VPWR VGND sky130_fd_sc_hd__decap_3
XFILLER_3_3 VGND VPWR VPWR VGND sky130_fd_sc_hd__decap_12
X_189_ VGND VPWR VPWR VGND _192_/CLK _189_/D fanout49/X _189_/Q sky130_fd_sc_hd__dfrtp_1
X_112_ VPWR VGND VGND VPWR _166_/A _112_/B _112_/Y sky130_fd_sc_hd__nor2_1
Xhold65 hold65/X _180_/Q VPWR VGND VGND VPWR sky130_fd_sc_hd__dlygate4sd3_1
Xhold54 _195_/D _094_/Y VPWR VGND VGND VPWR sky130_fd_sc_hd__dlygate4sd3_1
Xoutput9 VPWR VGND dout[5] _178_/Q VPWR VGND sky130_fd_sc_hd__buf_2
Xoutput11 VPWR VGND dout[7] _180_/Q VPWR VGND sky130_fd_sc_hd__buf_2
Xoutput22 VPWR VGND p[0] _096_/Y VPWR VGND sky130_fd_sc_hd__buf_2
Xoutput33 VPWR VGND stb _080_/Y VPWR VGND sky130_fd_sc_hd__buf_2
XFILLER_9_129 VGND VPWR VPWR VGND sky130_fd_sc_hd__decap_12
XFILLER_3_15 VPWR VGND VPWR VGND sky130_fd_sc_hd__decap_8
X_188_ VGND VPWR VPWR VGND _192_/CLK _188_/D fanout47/X _188_/Q sky130_fd_sc_hd__dfrtp_1
X_111_ VGND VPWR VPWR VGND _111_/X _191_/Q _166_/A hold59/X sky130_fd_sc_hd__mux2_1
Xhold55 hold55/X _172_/Q VPWR VGND VGND VPWR sky130_fd_sc_hd__dlygate4sd3_1
Xhold66 _079_/A _171_/Q VPWR VGND VGND VPWR sky130_fd_sc_hd__dlygate4sd3_1
XFILLER_20_57 VGND VPWR VPWR VGND sky130_fd_sc_hd__decap_4
Xoutput12 VPWR VGND eoc _201_/Q VPWR VGND sky130_fd_sc_hd__buf_2
Xoutput23 VPWR VGND p[1] _098_/Y VPWR VGND sky130_fd_sc_hd__buf_2
XFILLER_15_57 VGND VPWR VPWR VGND sky130_fd_sc_hd__decap_12
XFILLER_7_91 VGND VPWR VPWR VGND sky130_fd_sc_hd__decap_12
XFILLER_8_141 VGND VPWR VPWR VGND sky130_fd_sc_hd__decap_4
X_187_ VGND VPWR VPWR VGND _198_/CLK _187_/D fanout47/X _187_/Q sky130_fd_sc_hd__dfrtp_1
XFILLER_9_15 VGND VPWR VPWR VGND sky130_fd_sc_hd__decap_12
XPHY_EDGE_ROW_8_Left_29 VPWR VGND VPWR VGND sky130_fd_sc_hd__decap_3
X_110_ VPWR VGND VGND VPWR _193_/Q _110_/Y _110_/B sky130_fd_sc_hd__nand2_1
Xclkload0 VGND VPWR clkload0/X _198_/CLK VPWR VGND sky130_fd_sc_hd__clkbuf_1
XFILLER_1_60 VPWR VGND VPWR VGND sky130_fd_sc_hd__decap_3
Xhold56 _166_/B _175_/Q VPWR VGND VGND VPWR sky130_fd_sc_hd__dlygate4sd3_1
Xhold67 _171_/D _161_/Y VPWR VGND VGND VPWR sky130_fd_sc_hd__dlygate4sd3_1
XFILLER_10_80 VGND VPWR VPWR VGND sky130_fd_sc_hd__decap_4
Xoutput24 VPWR VGND p[2] _100_/Y VPWR VGND sky130_fd_sc_hd__buf_2
Xoutput13 VPWR VGND n[0] _095_/Y VPWR VGND sky130_fd_sc_hd__buf_2
XFILLER_15_69 VPWR VGND VPWR VGND sky130_fd_sc_hd__decap_8
XPHY_EDGE_ROW_19_Right_19 VPWR VGND VPWR VGND sky130_fd_sc_hd__decap_3
XFILLER_12_37 VGND VPWR VPWR VGND sky130_fd_sc_hd__decap_4
X_186_ VGND VPWR VPWR VGND _192_/CLK _186_/D fanout48/X _186_/Q sky130_fd_sc_hd__dfrtp_1
XFILLER_9_27 VGND VPWR VPWR VGND sky130_fd_sc_hd__decap_12
XFILLER_1_3 VPWR VGND VPWR VGND sky130_fd_sc_hd__decap_6
Xclkload1 VGND VPWR clkload1/X _201_/CLK VPWR VGND sky130_fd_sc_hd__clkbuf_1
X_169_ VGND VPWR VPWR VGND _177_/D _190_/Q _201_/D hold58/X sky130_fd_sc_hd__mux2_1
Xhold57 _164_/B _174_/Q VPWR VGND VGND VPWR sky130_fd_sc_hd__dlygate4sd3_1
Xhold68 _090_/B _181_/Q VPWR VGND VGND VPWR sky130_fd_sc_hd__dlygate4sd3_1
XFILLER_20_48 VGND VPWR VPWR VGND sky130_fd_sc_hd__decap_4
XFILLER_15_15 VGND VPWR VPWR VGND sky130_fd_sc_hd__decap_4
XPHY_EDGE_ROW_11_Left_32 VPWR VGND VPWR VGND sky130_fd_sc_hd__decap_3
Xoutput25 VPWR VGND p[3] _102_/Y VPWR VGND sky130_fd_sc_hd__buf_2
Xoutput14 VPWR VGND n[1] _097_/Y VPWR VGND sky130_fd_sc_hd__buf_2
XFILLER_5_113 VGND VPWR VPWR VGND sky130_fd_sc_hd__decap_12
XFILLER_0_19 VPWR VGND VPWR VGND sky130_fd_sc_hd__decap_8
X_185_ VPWR VGND VPWR VGND _185_/Q fanout48/X _185_/D _192_/CLK sky130_fd_sc_hd__dfstp_1
XFILLER_9_39 VPWR VGND VPWR VGND sky130_fd_sc_hd__decap_8
Xclkload2 VGND VPWR clkload2/X _192_/CLK VPWR VGND sky130_fd_sc_hd__clkbuf_1
X_168_ VGND VPWR VPWR VGND _176_/D _189_/Q _201_/D hold62/X sky130_fd_sc_hd__mux2_1
X_099_ VPWR VGND VGND VPWR _109_/B_N _188_/Q _099_/Y sky130_fd_sc_hd__nor2b_1
Xhold58 hold58/X _177_/Q VPWR VGND VGND VPWR sky130_fd_sc_hd__dlygate4sd3_1
Xhold69 hold69/X _197_/Q VPWR VGND VGND VPWR sky130_fd_sc_hd__dlygate4sd3_1
XFILLER_10_60 VPWR VGND VPWR VGND sky130_fd_sc_hd__decap_8
XPHY_EDGE_ROW_1_Right_1 VPWR VGND VPWR VGND sky130_fd_sc_hd__decap_3
Xoutput26 VPWR VGND p[4] _104_/Y VPWR VGND sky130_fd_sc_hd__buf_2
Xoutput15 VPWR VGND n[2] _099_/Y VPWR VGND sky130_fd_sc_hd__buf_2
XFILLER_5_125 VGND VPWR VPWR VGND sky130_fd_sc_hd__decap_12
XFILLER_13_82 VPWR VGND VPWR VGND sky130_fd_sc_hd__decap_3
X_184_ VPWR VGND VPWR VGND _184_/Q fanout49/X _184_/D _192_/CLK sky130_fd_sc_hd__dfstp_1
X_167_ VPWR VGND VPWR VGND _085_/Y _166_/A _166_/Y _175_/D sky130_fd_sc_hd__a21oi_1
X_098_ VPWR VGND VGND VPWR _187_/Q _098_/Y _110_/B sky130_fd_sc_hd__nand2_1
XFILLER_20_39 VGND VPWR VPWR VGND sky130_fd_sc_hd__decap_4
Xhold59 hold59/X _178_/Q VPWR VGND VGND VPWR sky130_fd_sc_hd__dlygate4sd3_1
Xoutput27 VPWR VGND p[5] _106_/Y VPWR VGND sky130_fd_sc_hd__buf_2
Xoutput16 VPWR VGND n[3] _101_/Y VPWR VGND sky130_fd_sc_hd__buf_2
XFILLER_15_28 VGND VPWR VPWR VGND sky130_fd_sc_hd__decap_12
Xclkbuf_0_clk VGND VPWR VGND VPWR clk clkbuf_0_clk/X sky130_fd_sc_hd__clkbuf_16
XFILLER_7_51 VGND VPWR VPWR VGND sky130_fd_sc_hd__decap_4
XPHY_EDGE_ROW_15_Right_15 VPWR VGND VPWR VGND sky130_fd_sc_hd__decap_3
XFILLER_12_141 VGND VPWR VPWR VGND sky130_fd_sc_hd__decap_4
XFILLER_5_137 VPWR VGND VPWR VGND sky130_fd_sc_hd__decap_8
XFILLER_4_63 VGND VPWR VPWR VGND sky130_fd_sc_hd__decap_12
Xfanout40 VGND VPWR VGND VPWR _194_/Q _109_/B_N sky130_fd_sc_hd__clkdlybuf4s50_1
X_183_ VPWR VGND VPWR VGND _183_/Q fanout48/X _183_/D _201_/CLK sky130_fd_sc_hd__dfstp_1
XFILLER_18_39 VGND VPWR VPWR VGND sky130_fd_sc_hd__decap_4
X_166_ VPWR VGND VGND VPWR _166_/A _166_/B _166_/Y sky130_fd_sc_hd__nor2_1
XFILLER_20_29 VPWR VGND VPWR VGND sky130_fd_sc_hd__decap_6
X_097_ VPWR VGND VGND VPWR _109_/B_N _187_/Q _097_/Y sky130_fd_sc_hd__nor2b_1
XFILLER_19_71 VPWR VGND VPWR VGND sky130_fd_sc_hd__decap_3
X_149_ VPWR VGND VPWR VGND _146_/Y _158_/B2 _149_/B1 _149_/X sky130_fd_sc_hd__a21o_1
Xoutput28 VPWR VGND p[6] _108_/Y VPWR VGND sky130_fd_sc_hd__buf_2
Xoutput17 VPWR VGND n[4] _103_/Y VPWR VGND sky130_fd_sc_hd__buf_2
XPHY_EDGE_ROW_15_Left_36 VPWR VGND VPWR VGND sky130_fd_sc_hd__decap_3
XFILLER_13_109 VPWR VGND VPWR VGND sky130_fd_sc_hd__decap_3
Xclkbuf_2_0__f_clk VGND VPWR VGND VPWR clkbuf_0_clk/X _200_/CLK sky130_fd_sc_hd__clkbuf_16
X_182_ VGND VPWR VPWR VGND _200_/CLK _182_/D fanout46/X _182_/Q sky130_fd_sc_hd__dfrtp_1
Xfanout41 VGND VPWR VGND VPWR _185_/Q _134_/A sky130_fd_sc_hd__clkdlybuf4s50_1
XPHY_EDGE_ROW_3_Left_24 VPWR VGND VPWR VGND sky130_fd_sc_hd__decap_3
X_165_ VPWR VGND VPWR VGND _166_/A _077_/Y _164_/Y _174_/D sky130_fd_sc_hd__a21oi_1
X_096_ VPWR VGND VGND VPWR _186_/Q _096_/Y _110_/B sky130_fd_sc_hd__nand2_1
XFILLER_19_61 VPWR VGND VPWR VGND sky130_fd_sc_hd__decap_6
XFILLER_19_137 VGND VPWR VPWR VGND sky130_fd_sc_hd__decap_4
X_148_ VPWR VGND VPWR VGND _147_/Y _190_/Q _145_/X _190_/D _158_/B2 sky130_fd_sc_hd__a22o_1
XFILLER_10_85 VGND VPWR VPWR VGND sky130_fd_sc_hd__decap_12
XFILLER_10_41 VPWR VGND VPWR VGND sky130_fd_sc_hd__decap_8
Xoutput29 VPWR VGND p[7] _110_/Y VPWR VGND sky130_fd_sc_hd__buf_2
Xoutput18 VPWR VGND n[5] _105_/Y VPWR VGND sky130_fd_sc_hd__buf_2
X_079_ VPWR VGND VGND VPWR _079_/A _079_/Y sky130_fd_sc_hd__inv_1
XFILLER_16_107 VGND VPWR VPWR VGND sky130_fd_sc_hd__decap_12
XPHY_EDGE_ROW_5_Right_5 VPWR VGND VPWR VGND sky130_fd_sc_hd__decap_3
XFILLER_16_95 VGND VPWR VPWR VGND sky130_fd_sc_hd__decap_12
X_181_ VGND VPWR VPWR VGND _200_/CLK _181_/D fanout46/X _181_/Q sky130_fd_sc_hd__dfrtp_1
Xfanout42 VGND VPWR VGND VPWR _184_/Q _130_/B sky130_fd_sc_hd__clkdlybuf4s50_1
X_164_ VPWR VGND VGND VPWR _166_/A _164_/B _164_/Y sky130_fd_sc_hd__nor2_1
X_095_ VPWR VGND VGND VPWR _109_/B_N _186_/Q _095_/Y sky130_fd_sc_hd__nor2b_1
XFILLER_10_97 VPWR VGND VPWR VGND sky130_fd_sc_hd__decap_6
X_147_ VGND VPWR VGND VPWR _146_/Y _140_/D _147_/Y _142_/X sky130_fd_sc_hd__o21ai_0
X_078_ VPWR VGND VGND VPWR _197_/Q _078_/Y sky130_fd_sc_hd__inv_1
Xoutput19 VPWR VGND n[6] _107_/Y VPWR VGND sky130_fd_sc_hd__buf_2
XFILLER_16_119 VGND VPWR VPWR VGND sky130_fd_sc_hd__decap_12
XFILLER_7_43 VGND VPWR VPWR VGND sky130_fd_sc_hd__decap_4
XFILLER_7_65 VPWR VGND VPWR VGND sky130_fd_sc_hd__decap_3
XPHY_EDGE_ROW_20_Right_20 VPWR VGND VPWR VGND sky130_fd_sc_hd__decap_3
XFILLER_16_85 VPWR VGND VPWR VGND sky130_fd_sc_hd__decap_3
XFILLER_16_41 VGND VPWR VPWR VGND sky130_fd_sc_hd__decap_12
XPHY_EDGE_ROW_11_Right_11 VPWR VGND VPWR VGND sky130_fd_sc_hd__decap_3
X_180_ VGND VPWR VPWR VGND _201_/CLK _180_/D fanout48/X _180_/Q sky130_fd_sc_hd__dfrtp_1
Xfanout43 VGND VPWR VGND VPWR _184_/Q _150_/B sky130_fd_sc_hd__clkdlybuf4s50_1
X_163_ VGND VPWR VPWR VGND _173_/D _186_/Q _166_/A hold61/X sky130_fd_sc_hd__mux2_1
X_094_ VGND VPWR VPWR VGND _084_/Y _181_/Q _090_/A _094_/Y _093_/Y sky130_fd_sc_hd__a31oi_1
XFILLER_19_128 VGND VPWR VPWR VGND sky130_fd_sc_hd__decap_4
XFILLER_10_21 VPWR VGND VPWR VGND sky130_fd_sc_hd__decap_6
X_146_ VPWR VGND VGND VPWR _146_/Y _146_/B _185_/Q _150_/B sky130_fd_sc_hd__nand3b_1
X_077_ VPWR VGND VGND VPWR _187_/Q _077_/Y sky130_fd_sc_hd__inv_1
X_129_ VGND VPWR VGND VPWR _186_/Q _092_/B _129_/Y _128_/Y sky130_fd_sc_hd__o21ai_0
XFILLER_16_53 VGND VPWR VPWR VGND sky130_fd_sc_hd__decap_12
XFILLER_16_20 VPWR VGND VPWR VGND sky130_fd_sc_hd__decap_8
XFILLER_8_127 VGND VPWR VPWR VGND sky130_fd_sc_hd__decap_12
XFILLER_4_141 VGND VPWR VPWR VGND sky130_fd_sc_hd__decap_4
Xfanout44 VGND VPWR VGND VPWR _183_/Q _134_/B sky130_fd_sc_hd__clkdlybuf4s50_1
XFILLER_1_133 VGND VPWR VPWR VGND sky130_fd_sc_hd__decap_12
X_162_ VPWR VGND VPWR VGND _127_/Y hold55/X _196_/D _172_/D sky130_fd_sc_hd__a21o_1
X_093_ VPWR VGND VGND VPWR _195_/Q _166_/A _093_/Y sky130_fd_sc_hd__nor2_1
Xinput1 VPWR VGND _140_/D cmp VPWR VGND sky130_fd_sc_hd__buf_2
XPHY_EDGE_ROW_7_Left_28 VPWR VGND VPWR VGND sky130_fd_sc_hd__decap_3
XFILLER_19_42 VGND VPWR VPWR VGND sky130_fd_sc_hd__decap_4
XFILLER_19_53 VPWR VGND VPWR VGND sky130_fd_sc_hd__decap_3
XFILLER_19_86 VPWR VGND VPWR VGND sky130_fd_sc_hd__decap_8
X_145_ VPWR VGND VPWR VGND _142_/X _158_/B2 _149_/B1 _145_/X sky130_fd_sc_hd__a21o_1
X_076_ VPWR VGND VGND VPWR _134_/A _076_/Y sky130_fd_sc_hd__inv_1
X_128_ VPWR VGND VGND VPWR _195_/Q _135_/A _197_/Q _128_/Y sky130_fd_sc_hd__nor3_1
XFILLER_16_65 VPWR VGND VPWR VGND sky130_fd_sc_hd__decap_8
XPHY_EDGE_ROW_9_Right_9 VPWR VGND VPWR VGND sky130_fd_sc_hd__decap_3
XFILLER_13_44 VPWR VGND VPWR VGND sky130_fd_sc_hd__decap_3
Xfanout45 VGND VPWR VGND VPWR _183_/Q _146_/B sky130_fd_sc_hd__clkdlybuf4s50_1
X_161_ VPWR VGND VPWR VGND _083_/Y _079_/Y _197_/Q _161_/Y sky130_fd_sc_hd__a21oi_1
X_092_ VGND VPWR VGND VPWR _092_/B _197_/Q _200_/D sky130_fd_sc_hd__or2_0
Xinput2 VPWR VGND input2/X rst_n VPWR VGND sky130_fd_sc_hd__buf_2
X_144_ VPWR VGND VPWR VGND _143_/Y _142_/X _141_/Y _189_/D sky130_fd_sc_hd__a21oi_1
XFILLER_18_141 VGND VPWR VPWR VGND sky130_fd_sc_hd__decap_4
XFILLER_7_57 VPWR VGND VPWR VGND sky130_fd_sc_hd__decap_8
X_127_ VPWR VGND VGND VPWR _135_/A _195_/Q _127_/Y sky130_fd_sc_hd__nor2_1
XFILLER_16_3 VPWR VGND VPWR VGND sky130_fd_sc_hd__decap_8
XFILLER_16_11 VPWR VGND VPWR VGND sky130_fd_sc_hd__decap_3
XPHY_EDGE_ROW_10_Left_31 VPWR VGND VPWR VGND sky130_fd_sc_hd__decap_3
Xfanout35 VGND VPWR VGND VPWR _199_/Q _166_/A sky130_fd_sc_hd__clkdlybuf4s50_1
Xfanout46 VGND VPWR VGND VPWR input2/X fanout46/X sky130_fd_sc_hd__clkdlybuf4s50_1
X_160_ VPWR VGND VPWR VGND _083_/Y _080_/Y _197_/D _170_/D sky130_fd_sc_hd__a21oi_1
X_091_ _092_/B _134_/A _134_/B _130_/B _135_/A VPWR VGND VGND VPWR sky130_fd_sc_hd__o31a_1
XPHY_EDGE_ROW_18_Right_18 VPWR VGND VPWR VGND sky130_fd_sc_hd__decap_3
XFILLER_19_99 VGND VPWR VPWR VGND sky130_fd_sc_hd__decap_4
XFILLER_19_109 VPWR VGND VPWR VGND sky130_fd_sc_hd__decap_3
X_143_ VGND VPWR VPWR VGND _150_/B _146_/B _076_/Y _143_/Y _189_/Q sky130_fd_sc_hd__a31oi_1
XFILLER_18_120 VGND VPWR VPWR VGND sky130_fd_sc_hd__decap_12
X_126_ VGND VPWR VGND VPWR _125_/Y _078_/Y _185_/D _135_/A sky130_fd_sc_hd__o21ai_0
XPHY_EDGE_ROW_0_Right_0 VPWR VGND VPWR VGND sky130_fd_sc_hd__decap_3
XFILLER_16_78 VPWR VGND VPWR VGND sky130_fd_sc_hd__decap_6
XFILLER_12_115 VGND VPWR VPWR VGND sky130_fd_sc_hd__decap_12
X_109_ VPWR VGND VGND VPWR _109_/B_N _193_/Q _109_/Y sky130_fd_sc_hd__nor2b_1
XFILLER_4_111 VGND VPWR VPWR VGND sky130_fd_sc_hd__decap_4
Xfanout36 VGND VPWR VGND VPWR _199_/Q _201_/D sky130_fd_sc_hd__clkdlybuf4s50_1
XFILLER_13_57 VGND VPWR VPWR VGND sky130_fd_sc_hd__decap_12
Xfanout47 VGND VPWR VGND VPWR input2/X fanout47/X sky130_fd_sc_hd__clkdlybuf4s50_1
XFILLER_6_3 VPWR VGND VPWR VGND sky130_fd_sc_hd__decap_3
X_090_ VGND VPWR _198_/D _090_/B _090_/A _195_/Q VPWR VGND sky130_fd_sc_hd__and3_1
Xclkbuf_2_1__f_clk VGND VPWR VGND VPWR clkbuf_0_clk/X _198_/CLK sky130_fd_sc_hd__clkbuf_16
X_142_ VGND VPWR VPWR VGND _150_/B _185_/Q _146_/B _142_/X sky130_fd_sc_hd__or3b_1
XFILLER_18_132 VPWR VGND VPWR VGND sky130_fd_sc_hd__decap_8
X_125_ VPWR VGND VGND VPWR _134_/A _125_/Y _125_/B sky130_fd_sc_hd__nand2_1
XFILLER_15_113 VGND VPWR VPWR VGND sky130_fd_sc_hd__decap_12
XFILLER_12_127 VGND VPWR VPWR VGND sky130_fd_sc_hd__decap_12
X_108_ VPWR VGND VGND VPWR _110_/B _108_/Y _192_/Q sky130_fd_sc_hd__nand2_1
Xfanout48 VGND VPWR VGND VPWR fanout49/X fanout48/X sky130_fd_sc_hd__clkdlybuf4s50_1
XFILLER_13_69 VPWR VGND VPWR VGND sky130_fd_sc_hd__decap_8
Xfanout37 VGND VPWR VGND VPWR _158_/B2 _135_/A sky130_fd_sc_hd__clkdlybuf4s50_1
XFILLER_8_7 VPWR VGND VPWR VGND sky130_fd_sc_hd__decap_6
X_141_ VPWR VGND VPWR VGND _158_/B2 _140_/Y _141_/Y _189_/Q _149_/B1 sky130_fd_sc_hd__a22oi_1
XFILLER_15_125 VGND VPWR VPWR VGND sky130_fd_sc_hd__decap_12
Xmax_cap34 VGND VPWR _149_/B1 _128_/Y VPWR VGND sky130_fd_sc_hd__buf_1
X_124_ VPWR VGND VPWR VGND _120_/Y _081_/Y _123_/Y _184_/D sky130_fd_sc_hd__a21oi_1
X_107_ VPWR VGND VGND VPWR _110_/B _192_/Q _107_/Y sky130_fd_sc_hd__nor2b_1
XPHY_EDGE_ROW_14_Left_35 VPWR VGND VPWR VGND sky130_fd_sc_hd__decap_3
XFILLER_4_135 VGND VPWR VPWR VGND sky130_fd_sc_hd__decap_4
Xfanout49 VGND VPWR VGND VPWR input2/X fanout49/X sky130_fd_sc_hd__clkdlybuf4s50_1
Xfanout38 VGND VPWR VGND VPWR _196_/Q _158_/B2 sky130_fd_sc_hd__clkdlybuf4s50_1
XPHY_EDGE_ROW_2_Left_23 VPWR VGND VPWR VGND sky130_fd_sc_hd__decap_3
XPHY_EDGE_ROW_14_Right_14 VPWR VGND VPWR VGND sky130_fd_sc_hd__decap_3
X_140_ VPWR VGND VGND VPWR _140_/Y _150_/B _146_/B _140_/D _185_/Q sky130_fd_sc_hd__nand4b_1
XFILLER_15_137 VPWR VGND VPWR VGND sky130_fd_sc_hd__decap_8
X_123_ VPWR VGND VPWR VGND _150_/B _146_/B _122_/Y _123_/Y sky130_fd_sc_hd__a21oi_1
X_106_ VPWR VGND VGND VPWR _191_/Q _106_/Y _110_/B sky130_fd_sc_hd__nand2_1
XFILLER_7_122 VGND VPWR VPWR VGND sky130_fd_sc_hd__decap_12
XPHY_EDGE_ROW_4_Right_4 VPWR VGND VPWR VGND sky130_fd_sc_hd__decap_3
XFILLER_8_93 VGND VPWR VPWR VGND sky130_fd_sc_hd__decap_12
XFILLER_4_29 VGND VPWR VPWR VGND sky130_fd_sc_hd__decap_12
Xfanout39 VGND VPWR VGND VPWR _109_/B_N _110_/B sky130_fd_sc_hd__clkdlybuf4s50_1
X_199_ VGND VPWR VPWR VGND _201_/CLK _199_/D fanout48/X _199_/Q sky130_fd_sc_hd__dfrtp_1
X_122_ VGND VPWR VGND VPWR _158_/B2 _146_/B _122_/Y _130_/B sky130_fd_sc_hd__o21ai_0
X_105_ VPWR VGND VGND VPWR _109_/B_N _191_/Q _105_/Y sky130_fd_sc_hd__nor2b_1
XFILLER_7_134 VGND VPWR VPWR VGND sky130_fd_sc_hd__decap_12
XFILLER_10_29 VGND VPWR VPWR VGND sky130_fd_sc_hd__decap_12
X_198_ VGND VPWR VPWR VGND _198_/CLK _198_/D fanout47/X _198_/Q sky130_fd_sc_hd__dfrtp_1
X_121_ VPWR VGND VGND VPWR _120_/Y _183_/D _158_/B2 _134_/B sky130_fd_sc_hd__mux2i_1
XFILLER_20_120 VGND VPWR VPWR VGND sky130_fd_sc_hd__decap_4
X_104_ VPWR VGND VGND VPWR _190_/Q _104_/Y _110_/B sky130_fd_sc_hd__nand2_1
XPHY_EDGE_ROW_18_Left_39 VPWR VGND VPWR VGND sky130_fd_sc_hd__decap_3
XFILLER_17_82 VGND VPWR VPWR VGND sky130_fd_sc_hd__decap_12
X_197_ VGND VPWR VPWR VGND _198_/CLK _197_/D fanout47/X _197_/Q sky130_fd_sc_hd__dfrtp_1
XFILLER_2_64 VGND VPWR VPWR VGND sky130_fd_sc_hd__decap_4
XPHY_EDGE_ROW_10_Right_10 VPWR VGND VPWR VGND sky130_fd_sc_hd__decap_3
XPHY_EDGE_ROW_6_Left_27 VPWR VGND VPWR VGND sky130_fd_sc_hd__decap_3
X_120_ VPWR VGND VPWR VGND _082_/Y _197_/Q _092_/B _120_/Y sky130_fd_sc_hd__a21oi_1
XFILLER_16_29 VGND VPWR VPWR VGND sky130_fd_sc_hd__decap_12
X_103_ VPWR VGND VGND VPWR _109_/B_N _190_/Q _103_/Y sky130_fd_sc_hd__nor2b_1
XFILLER_7_103 VPWR VGND VPWR VGND sky130_fd_sc_hd__decap_6
XFILLER_17_94 VGND VPWR VPWR VGND sky130_fd_sc_hd__decap_12
XPHY_EDGE_ROW_9_Left_30 VPWR VGND VPWR VGND sky130_fd_sc_hd__decap_3
XPHY_EDGE_ROW_8_Right_8 VPWR VGND VPWR VGND sky130_fd_sc_hd__decap_3
X_196_ VGND VPWR VPWR VGND _200_/CLK _196_/D fanout48/X _196_/Q sky130_fd_sc_hd__dfrtp_1
XFILLER_2_3 VGND VPWR VPWR VGND sky130_fd_sc_hd__decap_12
X_179_ VGND VPWR VPWR VGND _201_/CLK _179_/D fanout48/X _179_/Q sky130_fd_sc_hd__dfrtp_1
XFILLER_14_141 VGND VPWR VPWR VGND sky130_fd_sc_hd__decap_4
XFILLER_11_63 VGND VPWR VPWR VGND sky130_fd_sc_hd__decap_12
Xclkbuf_2_2__f_clk VGND VPWR VGND VPWR clkbuf_0_clk/X _201_/CLK sky130_fd_sc_hd__clkbuf_16
X_102_ VPWR VGND VGND VPWR _110_/B _102_/Y _189_/Q sky130_fd_sc_hd__nand2_1
XFILLER_0_132 VPWR VGND VPWR VGND sky130_fd_sc_hd__decap_3
XFILLER_4_7 VGND VPWR VPWR VGND sky130_fd_sc_hd__decap_12
X_195_ VPWR VGND VPWR VGND _195_/Q fanout46/X _195_/D _198_/CLK sky130_fd_sc_hd__dfstp_1
XFILLER_11_75 VGND VPWR VPWR VGND sky130_fd_sc_hd__decap_12
X_178_ VGND VPWR VPWR VGND _201_/CLK _178_/D fanout48/X _178_/Q sky130_fd_sc_hd__dfrtp_1
X_101_ VPWR VGND VGND VPWR _109_/B_N _189_/Q _101_/Y sky130_fd_sc_hd__nor2b_1
XFILLER_17_30 VPWR VGND VPWR VGND sky130_fd_sc_hd__decap_3
XFILLER_10_3 VPWR VGND VPWR VGND sky130_fd_sc_hd__decap_3
XFILLER_14_20 VPWR VGND VPWR VGND sky130_fd_sc_hd__decap_8
XFILLER_2_78 VPWR VGND VPWR VGND sky130_fd_sc_hd__decap_6
X_194_ VGND VPWR VPWR VGND _198_/CLK _194_/D fanout47/X _194_/Q sky130_fd_sc_hd__dfrtp_1
XFILLER_11_87 VGND VPWR VPWR VGND sky130_fd_sc_hd__decap_12
X_177_ VGND VPWR VPWR VGND _201_/CLK _177_/D fanout48/X _177_/Q sky130_fd_sc_hd__dfrtp_1
XFILLER_20_102 VGND VPWR VPWR VGND sky130_fd_sc_hd__decap_4
XFILLER_20_113 VPWR VGND VPWR VGND sky130_fd_sc_hd__decap_3
X_100_ VPWR VGND VGND VPWR _110_/B _100_/Y _188_/Q sky130_fd_sc_hd__nand2_1
XFILLER_11_113 VGND VPWR VPWR VGND sky130_fd_sc_hd__decap_12
XPHY_EDGE_ROW_17_Right_17 VPWR VGND VPWR VGND sky130_fd_sc_hd__decap_3
XFILLER_18_108 VGND VPWR VPWR VGND sky130_fd_sc_hd__decap_12
X_193_ VGND VPWR VPWR VGND _198_/CLK _193_/D fanout47/X _193_/Q sky130_fd_sc_hd__dfrtp_1
XFILLER_11_99 VGND VPWR VPWR VGND sky130_fd_sc_hd__decap_12
X_176_ VGND VPWR VPWR VGND _201_/CLK _176_/D fanout48/X _176_/Q sky130_fd_sc_hd__dfrtp_1
XFILLER_11_125 VGND VPWR VPWR VGND sky130_fd_sc_hd__decap_12
XFILLER_8_45 VPWR VGND VPWR VGND sky130_fd_sc_hd__decap_3
X_159_ VPWR VGND VPWR VGND _110_/B _083_/Y hold69/X _194_/D sky130_fd_sc_hd__a21o_1
XPHY_EDGE_ROW_13_Left_34 VPWR VGND VPWR VGND sky130_fd_sc_hd__decap_3
XFILLER_0_124 VPWR VGND VPWR VGND sky130_fd_sc_hd__decap_8
XFILLER_5_57 VGND VPWR VPWR VGND sky130_fd_sc_hd__decap_4
X_192_ VGND VPWR VPWR VGND _192_/CLK _192_/D fanout49/X _192_/Q sky130_fd_sc_hd__dfrtp_1
XPHY_EDGE_ROW_1_Left_22 VPWR VGND VPWR VGND sky130_fd_sc_hd__decap_3
X_175_ VGND VPWR VPWR VGND _200_/CLK _175_/D fanout46/X _175_/Q sky130_fd_sc_hd__dfrtp_1
XFILLER_11_137 VPWR VGND VPWR VGND sky130_fd_sc_hd__decap_8
X_158_ VPWR VGND VPWR VGND _193_/Q _127_/Y _193_/D _157_/Y _158_/B2 _197_/Q sky130_fd_sc_hd__a221o_1
X_089_ VPWR VGND VGND VPWR _134_/A _125_/B _199_/D sky130_fd_sc_hd__nor2_1
XFILLER_8_57 VGND VPWR VPWR VGND sky130_fd_sc_hd__decap_4
XFILLER_6_141 VGND VPWR VPWR VGND sky130_fd_sc_hd__decap_4
XFILLER_3_122 VGND VPWR VPWR VGND sky130_fd_sc_hd__decap_4
XPHY_EDGE_ROW_3_Right_3 VPWR VGND VPWR VGND sky130_fd_sc_hd__decap_3
XFILLER_2_15 VGND VPWR VPWR VGND sky130_fd_sc_hd__decap_12
X_191_ VGND VPWR VPWR VGND _192_/CLK _191_/D fanout49/X _191_/Q sky130_fd_sc_hd__dfrtp_1
X_174_ VGND VPWR VPWR VGND _200_/CLK _174_/D fanout46/X _174_/Q sky130_fd_sc_hd__dfrtp_1
XFILLER_14_113 VGND VPWR VPWR VGND sky130_fd_sc_hd__decap_12
X_088_ VGND VPWR VPWR VGND _130_/B _135_/A _134_/B _125_/B sky130_fd_sc_hd__or3b_1
X_157_ VGND VPWR _140_/D _157_/Y _156_/Y _134_/A _134_/B _130_/B VPWR VGND sky130_fd_sc_hd__a41oi_1
XFILLER_3_134 VGND VPWR VPWR VGND sky130_fd_sc_hd__decap_12
XPHY_EDGE_ROW_13_Right_13 VPWR VGND VPWR VGND sky130_fd_sc_hd__decap_3
XFILLER_17_133 VGND VPWR VPWR VGND sky130_fd_sc_hd__decap_12
X_190_ VGND VPWR VPWR VGND _192_/CLK _190_/D fanout49/X _190_/Q sky130_fd_sc_hd__dfrtp_1
X_173_ VGND VPWR VPWR VGND _200_/CLK _173_/D fanout46/X _173_/Q sky130_fd_sc_hd__dfrtp_1
XFILLER_14_125 VGND VPWR VPWR VGND sky130_fd_sc_hd__decap_12
XFILLER_11_25 VGND VPWR VPWR VGND sky130_fd_sc_hd__decap_12
X_087_ VPWR VGND VGND VPWR _140_/D _087_/Y sky130_fd_sc_hd__inv_1
X_156_ VGND VPWR VPWR VGND _130_/B _134_/B _134_/A _156_/Y _193_/Q sky130_fd_sc_hd__a31oi_1
XFILLER_8_37 VPWR VGND VPWR VGND sky130_fd_sc_hd__decap_8
XFILLER_17_57 VGND VPWR VPWR VGND sky130_fd_sc_hd__decap_12
X_139_ VGND VPWR VGND VPWR _138_/Y _085_/Y _188_/D _137_/Y sky130_fd_sc_hd__o21ai_0
XPHY_EDGE_ROW_17_Left_38 VPWR VGND VPWR VGND sky130_fd_sc_hd__decap_3
Xclkbuf_2_3__f_clk VGND VPWR VGND VPWR clkbuf_0_clk/X _192_/CLK sky130_fd_sc_hd__clkbuf_16
XFILLER_9_3 VGND VPWR VPWR VGND sky130_fd_sc_hd__decap_12
XFILLER_14_137 VPWR VGND VPWR VGND sky130_fd_sc_hd__decap_3
XFILLER_11_37 VGND VPWR VPWR VGND sky130_fd_sc_hd__decap_4
X_172_ VGND VPWR VPWR VGND _200_/CLK _172_/D fanout46/X _172_/Q sky130_fd_sc_hd__dfrtp_1
XFILLER_20_129 VGND VPWR VPWR VGND sky130_fd_sc_hd__decap_4
XFILLER_9_141 VGND VPWR VPWR VGND sky130_fd_sc_hd__decap_4
XPHY_EDGE_ROW_5_Left_26 VPWR VGND VPWR VGND sky130_fd_sc_hd__decap_3
XFILLER_0_7 VPWR VGND VPWR VGND sky130_fd_sc_hd__decap_8
X_086_ VPWR VGND VGND VPWR _192_/Q _086_/Y sky130_fd_sc_hd__inv_1
X_155_ VGND VPWR VGND VPWR _154_/Y _086_/Y _192_/D _153_/Y sky130_fd_sc_hd__o21ai_0
XFILLER_17_69 VPWR VGND VPWR VGND sky130_fd_sc_hd__decap_8
X_138_ VPWR VGND VGND VPWR _138_/Y _134_/B _087_/Y _076_/Y _135_/A _130_/B sky130_fd_sc_hd__o2111ai_1
XFILLER_0_117 VPWR VGND VPWR VGND sky130_fd_sc_hd__decap_3
XPHY_EDGE_ROW_7_Right_7 VPWR VGND VPWR VGND sky130_fd_sc_hd__decap_3
X_171_ VPWR VGND VPWR VGND _171_/Q fanout46/X _171_/D _198_/CLK sky130_fd_sc_hd__dfstp_1
XFILLER_6_101 VPWR VGND VPWR VGND sky130_fd_sc_hd__decap_3
XFILLER_10_141 VGND VPWR VPWR VGND sky130_fd_sc_hd__decap_4
X_085_ VPWR VGND VGND VPWR _188_/Q _085_/Y sky130_fd_sc_hd__inv_1
X_154_ VPWR VGND VGND VPWR _154_/Y _134_/B _087_/Y _134_/A _135_/A _130_/B sky130_fd_sc_hd__o2111ai_1
X_137_ VPWR VGND VGND VPWR _137_/Y _135_/B _082_/Y _078_/Y _127_/Y sky130_fd_sc_hd__a2bb2oi_1
Xsar_logic sar_logic/LO pd VPWR VGND VGND VPWR sky130_fd_sc_hd__conb_1
X_170_ VPWR VGND VPWR VGND _170_/Q fanout46/X _170_/D _198_/CLK sky130_fd_sc_hd__dfstp_1
XFILLER_3_84 VPWR VGND VPWR VGND sky130_fd_sc_hd__decap_8
X_084_ VPWR VGND VGND VPWR _166_/A _084_/Y sky130_fd_sc_hd__inv_1
X_153_ VPWR VGND VPWR VGND _150_/Y _158_/B2 _128_/Y _153_/Y sky130_fd_sc_hd__a21oi_1
XFILLER_10_120 VGND VPWR VPWR VGND sky130_fd_sc_hd__decap_12
X_136_ VPWR VGND VGND VPWR _140_/D _131_/Y _187_/D _077_/Y _135_/Y _133_/Y sky130_fd_sc_hd__o221ai_1
X_119_ VPWR VGND VGND VPWR _198_/D _119_/B _182_/D sky130_fd_sc_hd__nor2_1
XFILLER_20_93 VGND VPWR VPWR VGND sky130_fd_sc_hd__decap_4
XFILLER_6_40 VPWR VGND VPWR VGND sky130_fd_sc_hd__decap_6
X_152_ VPWR VGND VPWR VGND _151_/Y _191_/Q _149_/X _191_/D _158_/B2 sky130_fd_sc_hd__a22o_1
XFILLER_10_132 VPWR VGND VPWR VGND sky130_fd_sc_hd__decap_8
X_083_ VPWR VGND VGND VPWR _195_/Q _083_/Y sky130_fd_sc_hd__inv_1
XFILLER_6_125 VGND VPWR VPWR VGND sky130_fd_sc_hd__decap_12
X_135_ VPWR VGND VGND VPWR _135_/A _135_/Y _135_/B sky130_fd_sc_hd__nand2_1
X_118_ VGND VPWR VGND VPWR _084_/Y _090_/A _119_/B _117_/A sky130_fd_sc_hd__o21ai_0
XFILLER_14_29 VPWR VGND VPWR VGND sky130_fd_sc_hd__decap_3
XFILLER_6_85 VGND VPWR VPWR VGND sky130_fd_sc_hd__decap_4
XFILLER_15_50 VPWR VGND VPWR VGND sky130_fd_sc_hd__decap_6
Xoutput3 VPWR VGND cmp_clk _172_/Q VPWR VGND sky130_fd_sc_hd__buf_2
X_151_ VGND VPWR VGND VPWR _150_/Y _140_/D _151_/Y _146_/Y sky130_fd_sc_hd__o21ai_0
XFILLER_12_62 VGND VPWR VPWR VGND sky130_fd_sc_hd__decap_12
X_082_ VPWR VGND VGND VPWR _135_/A _082_/Y sky130_fd_sc_hd__inv_1
XFILLER_6_137 VPWR VGND VPWR VGND sky130_fd_sc_hd__decap_3
X_134_ VPWR VGND VGND VPWR _130_/B _134_/B _135_/B _134_/A sky130_fd_sc_hd__nor3b_1
X_117_ VPWR VGND VGND VPWR _117_/A _117_/B _181_/D sky130_fd_sc_hd__nor2_1
XFILLER_15_3 VGND VPWR VPWR VGND sky130_fd_sc_hd__decap_12
XPHY_EDGE_ROW_12_Left_33 VPWR VGND VPWR VGND sky130_fd_sc_hd__decap_3
Xhold60 _178_/D _111_/X VPWR VGND VGND VPWR sky130_fd_sc_hd__dlygate4sd3_1
XFILLER_17_106 VPWR VGND VPWR VGND sky130_fd_sc_hd__decap_6
Xoutput4 VPWR VGND dout[0] _173_/Q VPWR VGND sky130_fd_sc_hd__buf_2
XPHY_EDGE_ROW_0_Left_21 VPWR VGND VPWR VGND sky130_fd_sc_hd__decap_3
X_150_ VPWR VGND VGND VPWR _150_/Y _150_/B _185_/Q _134_/B sky130_fd_sc_hd__nand3b_1
XFILLER_12_85 VPWR VGND VPWR VGND sky130_fd_sc_hd__decap_8
XFILLER_12_74 VPWR VGND VPWR VGND sky130_fd_sc_hd__decap_8
X_081_ VPWR VGND VGND VPWR _130_/B _081_/Y sky130_fd_sc_hd__inv_1
XPHY_EDGE_ROW_16_Right_16 VPWR VGND VPWR VGND sky130_fd_sc_hd__decap_3
XFILLER_2_141 VGND VPWR VPWR VGND sky130_fd_sc_hd__decap_4
XFILLER_17_7 VPWR VGND VPWR VGND sky130_fd_sc_hd__decap_3
X_133_ VPWR VGND VGND VPWR _133_/Y _131_/B _082_/Y _078_/Y _127_/Y sky130_fd_sc_hd__a2bb2oi_1
XFILLER_9_97 VPWR VGND VPWR VGND sky130_fd_sc_hd__decap_3
X_116_ VPWR VGND VPWR VGND _084_/Y _195_/Q _090_/B _117_/B sky130_fd_sc_hd__a21oi_1
XPHY_EDGE_ROW_2_Right_2 VPWR VGND VPWR VGND sky130_fd_sc_hd__decap_3
Xhold61 hold61/X _173_/Q VPWR VGND VGND VPWR sky130_fd_sc_hd__dlygate4sd3_1
XFILLER_20_74 VPWR VGND VPWR VGND sky130_fd_sc_hd__decap_6
XFILLER_20_85 VGND VPWR VPWR VGND sky130_fd_sc_hd__decap_4
Xhold50 _197_/D _198_/Q VPWR VGND VGND VPWR sky130_fd_sc_hd__dlygate4sd3_1
Xoutput5 VPWR VGND dout[1] _174_/Q VPWR VGND sky130_fd_sc_hd__buf_2
X_080_ VPWR VGND VGND VPWR _080_/A _080_/Y sky130_fd_sc_hd__inv_1
XFILLER_5_3 VGND VPWR VPWR VGND sky130_fd_sc_hd__decap_4
X_201_ VGND VPWR VPWR VGND _201_/CLK _201_/D fanout49/X _201_/Q sky130_fd_sc_hd__dfrtp_1
XFILLER_2_131 VPWR VGND VPWR VGND sky130_fd_sc_hd__decap_8
X_132_ _131_/Y _134_/A _140_/D _186_/D _129_/Y _125_/B VPWR VGND VGND VPWR sky130_fd_sc_hd__o311ai_0
XFILLER_0_34 VPWR VGND VPWR VGND sky130_fd_sc_hd__decap_6
XFILLER_18_85 VPWR VGND VPWR VGND sky130_fd_sc_hd__decap_3
X_115_ VPWR VGND VGND VPWR _195_/Q _166_/A _090_/B _117_/A sky130_fd_sc_hd__o21a_1
Xhold62 hold62/X _176_/Q VPWR VGND VGND VPWR sky130_fd_sc_hd__dlygate4sd3_1
Xhold51 _196_/D _200_/Q VPWR VGND VGND VPWR sky130_fd_sc_hd__dlygate4sd3_1
Xoutput6 VPWR VGND dout[2] _175_/Q VPWR VGND sky130_fd_sc_hd__buf_2
Xoutput30 VPWR VGND s _171_/Q VPWR VGND sky130_fd_sc_hd__buf_2
XFILLER_15_86 VPWR VGND VPWR VGND sky130_fd_sc_hd__decap_3
XFILLER_16_141 VGND VPWR VPWR VGND sky130_fd_sc_hd__decap_4
.ends

.subckt sky130_fd_pr__cap_mim_m3_1_LFDY3D C2 C1
X0 C1 C2 sky130_fd_pr__cap_mim_m3_1 l=30 w=30
.ends

.subckt sky130_fd_pr__nfet_01v8_JSF6K7 B D S G
X0 S G D B sky130_fd_pr__nfet_01v8 ad=1.16 pd=8.58 as=1.16 ps=8.58 w=4 l=0.15
.ends

.subckt sky130_fd_pr__pfet_01v8_EA3B65 B D S G
X0 S G D B sky130_fd_pr__pfet_01v8 ad=2.32 pd=16.58 as=2.32 ps=16.58 w=8 l=0.15
.ends

.subckt afe vcm st stb VDD GND top refn
XCD GND refn sky130_fd_pr__cap_mim_m3_1_LFDY3D
XMT1 GND top vcm st sky130_fd_pr__nfet_01v8_JSF6K7
XMT2 VDD top vcm stb sky130_fd_pr__pfet_01v8_EA3B65
XMT3 GND vcm refn st sky130_fd_pr__nfet_01v8_JSF6K7
XMT4 VDD vcm refn stb sky130_fd_pr__pfet_01v8_EA3B65
.ends

.subckt sky130_fd_pr__nfet_01v8_PHAC7Z B D S G
X0 S G D B sky130_fd_pr__nfet_01v8 ad=0.145 pd=1.58 as=0.145 ps=1.58 w=0.5 l=0.15
.ends

.subckt sky130_fd_pr__pfet_01v8_7HN6Y2 B D S G
X0 S G D B sky130_fd_pr__pfet_01v8 ad=0.29 pd=2.58 as=0.29 ps=2.58 w=1 l=0.15
.ends

.subckt swunit vref p n s GND vin b VDD sb
XMN GND b GND n sky130_fd_pr__nfet_01v8_PHAC7Z
XMP VDD b vref p sky130_fd_pr__pfet_01v8_7HN6Y2
XMS1 GND vin b s sky130_fd_pr__nfet_01v8_PHAC7Z
XMS2 VDD vin b sb sky130_fd_pr__pfet_01v8_7HN6Y2
.ends

.subckt sky130_fd_pr__cap_mim_m3_1_4V3HYR C2 C1
X0 C1 C2 sky130_fd_pr__cap_mim_m3_1 l=2 w=2
.ends

.subckt cdac_array b0 b1 b2 b3 b4 b5 b6 bd top b7
XC12_3_b5 b5 top sky130_fd_pr__cap_mim_m3_1_4V3HYR
XC9_13_b7 b7 top sky130_fd_pr__cap_mim_m3_1_4V3HYR
XC0_15_b7 b7 top sky130_fd_pr__cap_mim_m3_1_4V3HYR
XC11_5_b6 b6 top sky130_fd_pr__cap_mim_m3_1_4V3HYR
XC10_4_b7 b7 top sky130_fd_pr__cap_mim_m3_1_4V3HYR
XC14_8_b3 b3 top sky130_fd_pr__cap_mim_m3_1_4V3HYR
XC13_7_b4 b4 top sky130_fd_pr__cap_mim_m3_1_4V3HYR
XC11_2_b7 b7 top sky130_fd_pr__cap_mim_m3_1_4V3HYR
XC7_10_b6 b6 top sky130_fd_pr__cap_mim_m3_1_4V3HYR
XC0_3_b5 b5 top sky130_fd_pr__cap_mim_m3_1_4V3HYR
XC13_1_b6 b6 top sky130_fd_pr__cap_mim_m3_1_4V3HYR
XC12_0_b7 b7 top sky130_fd_pr__cap_mim_m3_1_4V3HYR
XC8_13_b7 b7 top sky130_fd_pr__cap_mim_m3_1_4V3HYR
XC1_7_b4 b4 top sky130_fd_pr__cap_mim_m3_1_4V3HYR
XC2_8_b3 b3 top sky130_fd_pr__cap_mim_m3_1_4V3HYR
XC6_10_b6 b6 top sky130_fd_pr__cap_mim_m3_1_4V3HYR
XC0_0_b7 b7 top sky130_fd_pr__cap_mim_m3_1_4V3HYR
XC1_1_b6 b6 top sky130_fd_pr__cap_mim_m3_1_4V3HYR
XC7_13_b7 b7 top sky130_fd_pr__cap_mim_m3_1_4V3HYR
XC15_3_b5 b5 top sky130_fd_pr__cap_mim_m3_1_4V3HYR
XC12_6_b7 b7 top sky130_fd_pr__cap_mim_m3_1_4V3HYR
XC13_4_b7 b7 top sky130_fd_pr__cap_mim_m3_1_4V3HYR
XC14_5_b6 b6 top sky130_fd_pr__cap_mim_m3_1_4V3HYR
XC12_9_b7 b7 top sky130_fd_pr__cap_mim_m3_1_4V3HYR
XC5_8_b2 b2 top sky130_fd_pr__cap_mim_m3_1_4V3HYR
XC5_10_b6 b6 top sky130_fd_pr__cap_mim_m3_1_4V3HYR
XC15_14_b6 b6 top sky130_fd_pr__cap_mim_m3_1_4V3HYR
XC14_2_b7 b7 top sky130_fd_pr__cap_mim_m3_1_4V3HYR
XC0_6_b7 b7 top sky130_fd_pr__cap_mim_m3_1_4V3HYR
XC3_3_b5 b5 top sky130_fd_pr__cap_mim_m3_1_4V3HYR
XC15_11_b7 b7 top sky130_fd_pr__cap_mim_m3_1_4V3HYR
XC15_0_b7 b7 top sky130_fd_pr__cap_mim_m3_1_4V3HYR
XC6_13_b7 b7 top sky130_fd_pr__cap_mim_m3_1_4V3HYR
XC1_4_b7 b7 top sky130_fd_pr__cap_mim_m3_1_4V3HYR
XC0_9_b7 b7 top sky130_fd_pr__cap_mim_m3_1_4V3HYR
XC2_5_b6 b6 top sky130_fd_pr__cap_mim_m3_1_4V3HYR
XC2_2_b7 b7 top sky130_fd_pr__cap_mim_m3_1_4V3HYR
XC4_7_b4 b4 top sky130_fd_pr__cap_mim_m3_1_4V3HYR
XC3_0_b7 b7 top sky130_fd_pr__cap_mim_m3_1_4V3HYR
XC4_10_b6 b6 top sky130_fd_pr__cap_mim_m3_1_4V3HYR
XC14_14_b6 b6 top sky130_fd_pr__cap_mim_m3_1_4V3HYR
XC4_1_b6 b6 top sky130_fd_pr__cap_mim_m3_1_4V3HYR
XC5_13_b7 b7 top sky130_fd_pr__cap_mim_m3_1_4V3HYR
XC14_11_b7 b7 top sky130_fd_pr__cap_mim_m3_1_4V3HYR
XC15_6_b7 b7 top sky130_fd_pr__cap_mim_m3_1_4V3HYR
XC15_9_b7 b7 top sky130_fd_pr__cap_mim_m3_1_4V3HYR
XC13_14_b6 b6 top sky130_fd_pr__cap_mim_m3_1_4V3HYR
XC6_3_b5 b5 top sky130_fd_pr__cap_mim_m3_1_4V3HYR
XC3_6_b7 b7 top sky130_fd_pr__cap_mim_m3_1_4V3HYR
XC3_10_b6 b6 top sky130_fd_pr__cap_mim_m3_1_4V3HYR
XC13_11_b7 b7 top sky130_fd_pr__cap_mim_m3_1_4V3HYR
XC4_13_b7 b7 top sky130_fd_pr__cap_mim_m3_1_4V3HYR
XC4_4_b7 b7 top sky130_fd_pr__cap_mim_m3_1_4V3HYR
XC5_5_b6 b6 top sky130_fd_pr__cap_mim_m3_1_4V3HYR
XC7_7_b4 b4 top sky130_fd_pr__cap_mim_m3_1_4V3HYR
XC3_9_b7 b7 top sky130_fd_pr__cap_mim_m3_1_4V3HYR
XC5_2_b7 b7 top sky130_fd_pr__cap_mim_m3_1_4V3HYR
XC2_10_b6 b6 top sky130_fd_pr__cap_mim_m3_1_4V3HYR
XC12_14_b6 b6 top sky130_fd_pr__cap_mim_m3_1_4V3HYR
XC7_1_b6 b6 top sky130_fd_pr__cap_mim_m3_1_4V3HYR
XC6_0_b7 b7 top sky130_fd_pr__cap_mim_m3_1_4V3HYR
XC12_11_b7 b7 top sky130_fd_pr__cap_mim_m3_1_4V3HYR
XC3_13_b7 b7 top sky130_fd_pr__cap_mim_m3_1_4V3HYR
XC10_8_b2 b2 top sky130_fd_pr__cap_mim_m3_1_4V3HYR
XC11_14_b6 b6 top sky130_fd_pr__cap_mim_m3_1_4V3HYR
XC1_10_b6 b6 top sky130_fd_pr__cap_mim_m3_1_4V3HYR
XC9_3_b5 b5 top sky130_fd_pr__cap_mim_m3_1_4V3HYR
XC6_6_b7 b7 top sky130_fd_pr__cap_mim_m3_1_4V3HYR
XC2_13_b7 b7 top sky130_fd_pr__cap_mim_m3_1_4V3HYR
XC11_11_b7 b7 top sky130_fd_pr__cap_mim_m3_1_4V3HYR
XC7_4_b7 b7 top sky130_fd_pr__cap_mim_m3_1_4V3HYR
XC8_5_b6 b6 top sky130_fd_pr__cap_mim_m3_1_4V3HYR
XC6_9_b7 b7 top sky130_fd_pr__cap_mim_m3_1_4V3HYR
XC8_2_b7 b7 top sky130_fd_pr__cap_mim_m3_1_4V3HYR
XC0_10_b6 b6 top sky130_fd_pr__cap_mim_m3_1_4V3HYR
XC10_14_b6 b6 top sky130_fd_pr__cap_mim_m3_1_4V3HYR
XC9_0_b7 b7 top sky130_fd_pr__cap_mim_m3_1_4V3HYR
XC10_11_b7 b7 top sky130_fd_pr__cap_mim_m3_1_4V3HYR
XC1_13_b7 b7 top sky130_fd_pr__cap_mim_m3_1_4V3HYR
XC11_3_b5 b5 top sky130_fd_pr__cap_mim_m3_1_4V3HYR
XC9_14_b6 b6 top sky130_fd_pr__cap_mim_m3_1_4V3HYR
XC9_11_b7 b7 top sky130_fd_pr__cap_mim_m3_1_4V3HYR
XC9_6_b7 b7 top sky130_fd_pr__cap_mim_m3_1_4V3HYR
XC0_13_b7 b7 top sky130_fd_pr__cap_mim_m3_1_4V3HYR
XC12_7_b4 b4 top sky130_fd_pr__cap_mim_m3_1_4V3HYR
XC10_5_b6 b6 top sky130_fd_pr__cap_mim_m3_1_4V3HYR
XC13_8_b3 b3 top sky130_fd_pr__cap_mim_m3_1_4V3HYR
XC10_2_b7 b7 top sky130_fd_pr__cap_mim_m3_1_4V3HYR
XC11_0_b7 b7 top sky130_fd_pr__cap_mim_m3_1_4V3HYR
XC9_9_b7 b7 top sky130_fd_pr__cap_mim_m3_1_4V3HYR
XC12_1_b6 b6 top sky130_fd_pr__cap_mim_m3_1_4V3HYR
XC8_14_b6 b6 top sky130_fd_pr__cap_mim_m3_1_4V3HYR
XC0_7_b4 b4 top sky130_fd_pr__cap_mim_m3_1_4V3HYR
XC8_11_b7 b7 top sky130_fd_pr__cap_mim_m3_1_4V3HYR
XC1_8_b3 b3 top sky130_fd_pr__cap_mim_m3_1_4V3HYR
XC0_1_b6 b6 top sky130_fd_pr__cap_mim_m3_1_4V3HYR
XC14_3_b5 b5 top sky130_fd_pr__cap_mim_m3_1_4V3HYR
XC11_6_b7 b7 top sky130_fd_pr__cap_mim_m3_1_4V3HYR
XC7_14_b6 b6 top sky130_fd_pr__cap_mim_m3_1_4V3HYR
XC7_11_b7 b7 top sky130_fd_pr__cap_mim_m3_1_4V3HYR
XC15_12_b5 b5 top sky130_fd_pr__cap_mim_m3_1_4V3HYR
XC13_5_b6 b6 top sky130_fd_pr__cap_mim_m3_1_4V3HYR
XC12_4_b7 b7 top sky130_fd_pr__cap_mim_m3_1_4V3HYR
XC15_7_b4 b4 top sky130_fd_pr__cap_mim_m3_1_4V3HYR
XC13_2_b7 b7 top sky130_fd_pr__cap_mim_m3_1_4V3HYR
XC11_9_b7 b7 top sky130_fd_pr__cap_mim_m3_1_4V3HYR
XC2_3_b5 b5 top sky130_fd_pr__cap_mim_m3_1_4V3HYR
XC4_8_b2 b2 top sky130_fd_pr__cap_mim_m3_1_4V3HYR
XC15_1_b6 b6 top sky130_fd_pr__cap_mim_m3_1_4V3HYR
XC14_0_b7 b7 top sky130_fd_pr__cap_mim_m3_1_4V3HYR
XC7_8_b0 b0 top sky130_fd_pr__cap_mim_m3_1_4V3HYR
XC6_14_b6 b6 top sky130_fd_pr__cap_mim_m3_1_4V3HYR
XC0_4_b7 b7 top sky130_fd_pr__cap_mim_m3_1_4V3HYR
XC1_5_b6 b6 top sky130_fd_pr__cap_mim_m3_1_4V3HYR
XC14_12_b5 b5 top sky130_fd_pr__cap_mim_m3_1_4V3HYR
XC6_11_b7 b7 top sky130_fd_pr__cap_mim_m3_1_4V3HYR
XC1_2_b7 b7 top sky130_fd_pr__cap_mim_m3_1_4V3HYR
XC3_7_b4 b4 top sky130_fd_pr__cap_mim_m3_1_4V3HYR
XC2_0_b7 b7 top sky130_fd_pr__cap_mim_m3_1_4V3HYR
XC3_1_b6 b6 top sky130_fd_pr__cap_mim_m3_1_4V3HYR
XC5_14_b6 b6 top sky130_fd_pr__cap_mim_m3_1_4V3HYR
XC14_6_b7 b7 top sky130_fd_pr__cap_mim_m3_1_4V3HYR
XC5_11_b7 b7 top sky130_fd_pr__cap_mim_m3_1_4V3HYR
XC15_15_b7 b7 top sky130_fd_pr__cap_mim_m3_1_4V3HYR
XC15_4_b7 b7 top sky130_fd_pr__cap_mim_m3_1_4V3HYR
XC13_12_b5 b5 top sky130_fd_pr__cap_mim_m3_1_4V3HYR
XC14_9_b7 b7 top sky130_fd_pr__cap_mim_m3_1_4V3HYR
XC2_6_b7 b7 top sky130_fd_pr__cap_mim_m3_1_4V3HYR
XC5_3_b5 b5 top sky130_fd_pr__cap_mim_m3_1_4V3HYR
XC3_4_b7 b7 top sky130_fd_pr__cap_mim_m3_1_4V3HYR
XC4_14_b6 b6 top sky130_fd_pr__cap_mim_m3_1_4V3HYR
XC12_12_b5 b5 top sky130_fd_pr__cap_mim_m3_1_4V3HYR
XC2_9_b7 b7 top sky130_fd_pr__cap_mim_m3_1_4V3HYR
XC4_5_b6 b6 top sky130_fd_pr__cap_mim_m3_1_4V3HYR
XC4_11_b7 b7 top sky130_fd_pr__cap_mim_m3_1_4V3HYR
XC14_15_b7 b7 top sky130_fd_pr__cap_mim_m3_1_4V3HYR
XC6_7_b4 b4 top sky130_fd_pr__cap_mim_m3_1_4V3HYR
XC4_2_b7 b7 top sky130_fd_pr__cap_mim_m3_1_4V3HYR
XC5_0_b7 b7 top sky130_fd_pr__cap_mim_m3_1_4V3HYR
XC6_1_b6 b6 top sky130_fd_pr__cap_mim_m3_1_4V3HYR
XC3_14_b6 b6 top sky130_fd_pr__cap_mim_m3_1_4V3HYR
XC13_15_b7 b7 top sky130_fd_pr__cap_mim_m3_1_4V3HYR
XC11_12_b5 b5 top sky130_fd_pr__cap_mim_m3_1_4V3HYR
XC3_11_b7 b7 top sky130_fd_pr__cap_mim_m3_1_4V3HYR
XC8_8_bd bd top sky130_fd_pr__cap_mim_m3_1_4V3HYR
XC8_3_b5 b5 top sky130_fd_pr__cap_mim_m3_1_4V3HYR
XC5_6_b7 b7 top sky130_fd_pr__cap_mim_m3_1_4V3HYR
XC2_14_b6 b6 top sky130_fd_pr__cap_mim_m3_1_4V3HYR
XC10_12_b5 b5 top sky130_fd_pr__cap_mim_m3_1_4V3HYR
XC7_5_b6 b6 top sky130_fd_pr__cap_mim_m3_1_4V3HYR
XC6_4_b7 b7 top sky130_fd_pr__cap_mim_m3_1_4V3HYR
XC2_11_b7 b7 top sky130_fd_pr__cap_mim_m3_1_4V3HYR
XC12_15_b7 b7 top sky130_fd_pr__cap_mim_m3_1_4V3HYR
XC9_7_b4 b4 top sky130_fd_pr__cap_mim_m3_1_4V3HYR
XC7_2_b7 b7 top sky130_fd_pr__cap_mim_m3_1_4V3HYR
XC5_9_b7 b7 top sky130_fd_pr__cap_mim_m3_1_4V3HYR
XC9_1_b6 b6 top sky130_fd_pr__cap_mim_m3_1_4V3HYR
XC8_0_b7 b7 top sky130_fd_pr__cap_mim_m3_1_4V3HYR
XC1_14_b6 b6 top sky130_fd_pr__cap_mim_m3_1_4V3HYR
XC11_15_b7 b7 top sky130_fd_pr__cap_mim_m3_1_4V3HYR
XC9_12_b5 b5 top sky130_fd_pr__cap_mim_m3_1_4V3HYR
XC1_11_b7 b7 top sky130_fd_pr__cap_mim_m3_1_4V3HYR
XC10_3_b5 b5 top sky130_fd_pr__cap_mim_m3_1_4V3HYR
XC8_6_b7 b7 top sky130_fd_pr__cap_mim_m3_1_4V3HYR
XC0_14_b6 b6 top sky130_fd_pr__cap_mim_m3_1_4V3HYR
XC12_8_b3 b3 top sky130_fd_pr__cap_mim_m3_1_4V3HYR
XC11_7_b4 b4 top sky130_fd_pr__cap_mim_m3_1_4V3HYR
XC9_4_b7 b7 top sky130_fd_pr__cap_mim_m3_1_4V3HYR
XC8_12_b5 b5 top sky130_fd_pr__cap_mim_m3_1_4V3HYR
XC0_11_b7 b7 top sky130_fd_pr__cap_mim_m3_1_4V3HYR
XC10_15_b7 b7 top sky130_fd_pr__cap_mim_m3_1_4V3HYR
XC8_9_b7 b7 top sky130_fd_pr__cap_mim_m3_1_4V3HYR
XC11_1_b6 b6 top sky130_fd_pr__cap_mim_m3_1_4V3HYR
XC10_0_b7 b7 top sky130_fd_pr__cap_mim_m3_1_4V3HYR
XC0_8_b3 b3 top sky130_fd_pr__cap_mim_m3_1_4V3HYR
XC9_15_b7 b7 top sky130_fd_pr__cap_mim_m3_1_4V3HYR
XC7_12_b5 b5 top sky130_fd_pr__cap_mim_m3_1_4V3HYR
XC13_3_b5 b5 top sky130_fd_pr__cap_mim_m3_1_4V3HYR
XC10_6_b7 b7 top sky130_fd_pr__cap_mim_m3_1_4V3HYR
XC11_4_b7 b7 top sky130_fd_pr__cap_mim_m3_1_4V3HYR
XC14_7_b4 b4 top sky130_fd_pr__cap_mim_m3_1_4V3HYR
XC12_5_b6 b6 top sky130_fd_pr__cap_mim_m3_1_4V3HYR
XC10_9_b7 b7 top sky130_fd_pr__cap_mim_m3_1_4V3HYR
XC6_12_b5 b5 top sky130_fd_pr__cap_mim_m3_1_4V3HYR
XC15_8_b3 b3 top sky130_fd_pr__cap_mim_m3_1_4V3HYR
XC12_2_b7 b7 top sky130_fd_pr__cap_mim_m3_1_4V3HYR
XC8_15_b7 b7 top sky130_fd_pr__cap_mim_m3_1_4V3HYR
XC1_3_b5 b5 top sky130_fd_pr__cap_mim_m3_1_4V3HYR
XC13_0_b7 b7 top sky130_fd_pr__cap_mim_m3_1_4V3HYR
XC14_1_b6 b6 top sky130_fd_pr__cap_mim_m3_1_4V3HYR
XC0_5_b6 b6 top sky130_fd_pr__cap_mim_m3_1_4V3HYR
XC15_10_b6 b6 top sky130_fd_pr__cap_mim_m3_1_4V3HYR
XC0_2_b7 b7 top sky130_fd_pr__cap_mim_m3_1_4V3HYR
XC2_7_b4 b4 top sky130_fd_pr__cap_mim_m3_1_4V3HYR
XC3_8_b3 b3 top sky130_fd_pr__cap_mim_m3_1_4V3HYR
XC7_15_b7 b7 top sky130_fd_pr__cap_mim_m3_1_4V3HYR
XC1_0_b7 b7 top sky130_fd_pr__cap_mim_m3_1_4V3HYR
XC5_12_b5 b5 top sky130_fd_pr__cap_mim_m3_1_4V3HYR
XC6_8_b1 b1 top sky130_fd_pr__cap_mim_m3_1_4V3HYR
XC2_1_b6 b6 top sky130_fd_pr__cap_mim_m3_1_4V3HYR
XC13_6_b7 b7 top sky130_fd_pr__cap_mim_m3_1_4V3HYR
XC14_10_b6 b6 top sky130_fd_pr__cap_mim_m3_1_4V3HYR
XC15_5_b6 b6 top sky130_fd_pr__cap_mim_m3_1_4V3HYR
XC14_4_b7 b7 top sky130_fd_pr__cap_mim_m3_1_4V3HYR
XC4_12_b5 b5 top sky130_fd_pr__cap_mim_m3_1_4V3HYR
XC15_13_b7 b7 top sky130_fd_pr__cap_mim_m3_1_4V3HYR
XC15_2_b7 b7 top sky130_fd_pr__cap_mim_m3_1_4V3HYR
XC13_9_b7 b7 top sky130_fd_pr__cap_mim_m3_1_4V3HYR
XC6_15_b7 b7 top sky130_fd_pr__cap_mim_m3_1_4V3HYR
XC1_6_b7 b7 top sky130_fd_pr__cap_mim_m3_1_4V3HYR
XC4_3_b5 b5 top sky130_fd_pr__cap_mim_m3_1_4V3HYR
XC2_4_b7 b7 top sky130_fd_pr__cap_mim_m3_1_4V3HYR
XC3_5_b6 b6 top sky130_fd_pr__cap_mim_m3_1_4V3HYR
XC13_10_b6 b6 top sky130_fd_pr__cap_mim_m3_1_4V3HYR
XC1_9_b7 b7 top sky130_fd_pr__cap_mim_m3_1_4V3HYR
XC3_2_b7 b7 top sky130_fd_pr__cap_mim_m3_1_4V3HYR
XC5_7_b4 b4 top sky130_fd_pr__cap_mim_m3_1_4V3HYR
XC3_12_b5 b5 top sky130_fd_pr__cap_mim_m3_1_4V3HYR
XC5_15_b7 b7 top sky130_fd_pr__cap_mim_m3_1_4V3HYR
XC14_13_b7 b7 top sky130_fd_pr__cap_mim_m3_1_4V3HYR
XC4_0_b7 b7 top sky130_fd_pr__cap_mim_m3_1_4V3HYR
XC5_1_b6 b6 top sky130_fd_pr__cap_mim_m3_1_4V3HYR
XC9_8_b1 b1 top sky130_fd_pr__cap_mim_m3_1_4V3HYR
XC12_10_b6 b6 top sky130_fd_pr__cap_mim_m3_1_4V3HYR
XC13_13_b7 b7 top sky130_fd_pr__cap_mim_m3_1_4V3HYR
XC2_12_b5 b5 top sky130_fd_pr__cap_mim_m3_1_4V3HYR
XC4_15_b7 b7 top sky130_fd_pr__cap_mim_m3_1_4V3HYR
XC7_3_b5 b5 top sky130_fd_pr__cap_mim_m3_1_4V3HYR
XC4_6_b7 b7 top sky130_fd_pr__cap_mim_m3_1_4V3HYR
XC5_4_b7 b7 top sky130_fd_pr__cap_mim_m3_1_4V3HYR
XC6_5_b6 b6 top sky130_fd_pr__cap_mim_m3_1_4V3HYR
XC4_9_b7 b7 top sky130_fd_pr__cap_mim_m3_1_4V3HYR
XC11_10_b6 b6 top sky130_fd_pr__cap_mim_m3_1_4V3HYR
XC8_7_b4 b4 top sky130_fd_pr__cap_mim_m3_1_4V3HYR
XC6_2_b7 b7 top sky130_fd_pr__cap_mim_m3_1_4V3HYR
XC1_12_b5 b5 top sky130_fd_pr__cap_mim_m3_1_4V3HYR
XC3_15_b7 b7 top sky130_fd_pr__cap_mim_m3_1_4V3HYR
XC12_13_b7 b7 top sky130_fd_pr__cap_mim_m3_1_4V3HYR
XC7_0_b7 b7 top sky130_fd_pr__cap_mim_m3_1_4V3HYR
XC8_1_b6 b6 top sky130_fd_pr__cap_mim_m3_1_4V3HYR
XC10_10_b6 b6 top sky130_fd_pr__cap_mim_m3_1_4V3HYR
XC11_8_b2 b2 top sky130_fd_pr__cap_mim_m3_1_4V3HYR
XC11_13_b7 b7 top sky130_fd_pr__cap_mim_m3_1_4V3HYR
XC0_12_b5 b5 top sky130_fd_pr__cap_mim_m3_1_4V3HYR
XC2_15_b7 b7 top sky130_fd_pr__cap_mim_m3_1_4V3HYR
XC7_6_b7 b7 top sky130_fd_pr__cap_mim_m3_1_4V3HYR
XC10_7_b4 b4 top sky130_fd_pr__cap_mim_m3_1_4V3HYR
XC9_10_b6 b6 top sky130_fd_pr__cap_mim_m3_1_4V3HYR
XC9_5_b6 b6 top sky130_fd_pr__cap_mim_m3_1_4V3HYR
XC8_4_b7 b7 top sky130_fd_pr__cap_mim_m3_1_4V3HYR
XC9_2_b7 b7 top sky130_fd_pr__cap_mim_m3_1_4V3HYR
XC7_9_b7 b7 top sky130_fd_pr__cap_mim_m3_1_4V3HYR
XC10_13_b7 b7 top sky130_fd_pr__cap_mim_m3_1_4V3HYR
XC10_1_b6 b6 top sky130_fd_pr__cap_mim_m3_1_4V3HYR
XC1_15_b7 b7 top sky130_fd_pr__cap_mim_m3_1_4V3HYR
XC8_10_b6 b6 top sky130_fd_pr__cap_mim_m3_1_4V3HYR
.ends

.subckt cdac_full p7 n7 p6 n6 p5 n5 p4 n4 p3 n3 p2 n2 p1 n1 p0 n0 pd nd b7 b6 b5 b4
+ b3 b2 b1 b0 bd s GND sb vref VDD top vin
XSW28 vref p4 n4 s GND vin b4 VDD sb swunit
XSW17 vref p6 n6 s GND vin b6 VDD sb swunit
XSW9 vref p7 n7 s GND vin b7 VDD sb swunit
XSW29 vref p4 n4 s GND vin b4 VDD sb swunit
XSW18 vref p6 n6 s GND vin b6 VDD sb swunit
XSW19 vref p6 n6 s GND vin b6 VDD sb swunit
XSW30 vref p3 n3 s GND vin b3 VDD sb swunit
XSW0 vref p7 n7 s GND vin b7 VDD sb swunit
XSW32 vref p1 n1 s GND vin b1 VDD sb swunit
XSW31 vref p2 n2 s GND vin b2 VDD sb swunit
XSW21 vref p6 n6 s GND vin b6 VDD sb swunit
XSW20 vref p6 n6 s GND vin b6 VDD sb swunit
XSW10 vref p7 n7 s GND vin b7 VDD sb swunit
XSW1 vref p7 n7 s GND vin b7 VDD sb swunit
XSW2 vref p7 n7 s GND vin b7 VDD sb swunit
XSW33 vref p0 n0 s GND vin b0 VDD sb swunit
XSW22 vref p6 n6 s GND vin b6 VDD sb swunit
XSW11 vref p7 n7 s GND vin b7 VDD sb swunit
XSW3 vref p7 n7 s GND vin b7 VDD sb swunit
XSW34 vref pd nd s GND vin bd VDD sb swunit
XSW23 vref p6 n6 s GND vin b6 VDD sb swunit
XSW12 vref p7 n7 s GND vin b7 VDD sb swunit
XSW4 vref p7 n7 s GND vin b7 VDD sb swunit
XSW24 vref p5 n5 s GND vin b5 VDD sb swunit
XSW13 vref p7 n7 s GND vin b7 VDD sb swunit
XSW5 vref p7 n7 s GND vin b7 VDD sb swunit
XSW25 vref p5 n5 s GND vin b5 VDD sb swunit
XSW14 vref p7 n7 s GND vin b7 VDD sb swunit
XSW6 vref p7 n7 s GND vin b7 VDD sb swunit
XSW26 vref p5 n5 s GND vin b5 VDD sb swunit
XSW15 vref p7 n7 s GND vin b7 VDD sb swunit
XSW7 vref p7 n7 s GND vin b7 VDD sb swunit
XARRAY b0 b1 b2 b3 b4 b5 b6 bd top b7 cdac_array
XSW27 vref p5 n5 s GND vin b5 VDD sb swunit
XSW16 vref p6 n6 s GND vin b6 VDD sb swunit
XSW8 vref p7 n7 s GND vin b7 VDD sb swunit
.ends

.subckt sky130_fd_pr__nfet_01v8_NK2ZG9 B D S G
X0 S G D B sky130_fd_pr__nfet_01v8 ad=0.58 pd=4.58 as=0.58 ps=4.58 w=2 l=0.15
.ends

.subckt sky130_fd_pr__nfet_01v8_TPXDG7 B D S G
X0 S G D B sky130_fd_pr__nfet_01v8 ad=2.32 pd=16.58 as=2.32 ps=16.58 w=8 l=1
.ends

.subckt sky130_fd_pr__nfet_01v8_34VMYE B D S G
X0 S G D B sky130_fd_pr__nfet_01v8 ad=0.29 pd=2.58 as=0.29 ps=2.58 w=1 l=0.15
.ends

.subckt sky130_fd_pr__pfet_01v8_VJT448 B D S G
X0 S G D B sky130_fd_pr__pfet_01v8 ad=0.58 pd=4.58 as=0.58 ps=4.58 w=2 l=0.15
.ends

.subckt comp clk inp inn outp outn VDD GND
XM10 VDD M4/S VDD clk sky130_fd_pr__pfet_01v8_7HN6Y2
XM0 GND GND M2/D clk sky130_fd_pr__nfet_01v8_NK2ZG9
XM1 GND M9/S M2/D inp sky130_fd_pr__nfet_01v8_TPXDG7
XM2 GND M2/D M4/S inn sky130_fd_pr__nfet_01v8_TPXDG7
XM4 GND outp M4/S outn sky130_fd_pr__nfet_01v8_34VMYE
XM3 GND M9/S outn outp sky130_fd_pr__nfet_01v8_34VMYE
XM5 VDD VDD outn outp sky130_fd_pr__pfet_01v8_VJT448
XM6 VDD outp VDD outn sky130_fd_pr__pfet_01v8_VJT448
XM7 VDD VDD outn clk sky130_fd_pr__pfet_01v8_7HN6Y2
XM8 VDD outp VDD clk sky130_fd_pr__pfet_01v8_7HN6Y2
XM9 VDD VDD M9/S clk sky130_fd_pr__pfet_01v8_7HN6Y2
.ends

.subckt adc_top VDD GND vin vref vcm clk rst_n dout0 dout1 dout2 dout3 dout4 dout5
+ dout6 dout7 eoc
XSAR clk SAR/cmp COMP/clk dout0 dout1 dout2 dout3 dout4 dout5 dout6 dout7 eoc CDAC/n0
+ CDAC/n1 CDAC/n2 CDAC/n3 CDAC/n4 CDAC/n5 CDAC/n6 CDAC/n7 SAR/nd CDAC/p0 CDAC/p1 CDAC/p2
+ CDAC/p3 CDAC/p4 CDAC/p5 CDAC/p6 CDAC/p7 SAR/pd rst_n SAR/s SAR/sb SAR/st SAR/stb
+ VDD GND sar_logic
XAFE vcm SAR/st SAR/stb VDD GND AFE/top COMP/inp afe
XCDAC CDAC/p7 CDAC/n7 CDAC/p6 CDAC/n6 CDAC/p5 CDAC/n5 CDAC/p4 CDAC/n4 CDAC/p3 CDAC/n3
+ CDAC/p2 CDAC/n2 CDAC/p1 CDAC/n1 CDAC/p0 CDAC/n0 SAR/pd SAR/nd CDAC/b7 CDAC/b6 CDAC/b5
+ CDAC/b4 CDAC/b3 CDAC/b2 CDAC/b1 CDAC/b0 CDAC/bd SAR/s GND SAR/sb vref VDD AFE/top
+ vin cdac_full
XCOMP COMP/clk COMP/inp AFE/top COMP/outp SAR/cmp VDD GND comp
.ends
