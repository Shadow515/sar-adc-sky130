* NGSPICE file created from afe.ext - technology: sky130A

.subckt sky130_fd_pr__cap_mim_m3_1_LFDY3D C2 C1
X0 C1 C2 sky130_fd_pr__cap_mim_m3_1 l=30 w=30
.ends

.subckt sky130_fd_pr__nfet_01v8_JSF6K7 B D S G
X0 S G D B sky130_fd_pr__nfet_01v8 ad=1.16 pd=8.58 as=1.16 ps=8.58 w=4 l=0.15
.ends

.subckt sky130_fd_pr__pfet_01v8_EA3B65 B D S G
X0 S G D B sky130_fd_pr__pfet_01v8 ad=2.32 pd=16.58 as=2.32 ps=16.58 w=8 l=0.15
.ends

.subckt afe top refn vcm st stb VDD GND
XCD GND refn sky130_fd_pr__cap_mim_m3_1_LFDY3D
XMT1 GND top vcm st sky130_fd_pr__nfet_01v8_JSF6K7
XMT2 VDD top vcm stb sky130_fd_pr__pfet_01v8_EA3B65
XMT3 GND vcm refn st sky130_fd_pr__nfet_01v8_JSF6K7
XMT4 VDD vcm refn stb sky130_fd_pr__pfet_01v8_EA3B65
.ends
